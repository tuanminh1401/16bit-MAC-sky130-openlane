* NGSPICE file created from mac_16bit.ext - technology: sky130A

* Black-box entry subcircuit for sky130_fd_sc_hd__tapvpwrvgnd_1 abstract view
.subckt sky130_fd_sc_hd__tapvpwrvgnd_1 VGND VPWR
.ends

* Black-box entry subcircuit for sky130_fd_sc_hd__clkbuf_2 abstract view
.subckt sky130_fd_sc_hd__clkbuf_2 A VGND VNB VPB VPWR X
.ends

* Black-box entry subcircuit for sky130_fd_sc_hd__a21o_1 abstract view
.subckt sky130_fd_sc_hd__a21o_1 A1 A2 B1 VGND VNB VPB VPWR X
.ends

* Black-box entry subcircuit for sky130_fd_sc_hd__decap_6 abstract view
.subckt sky130_fd_sc_hd__decap_6 VGND VNB VPB VPWR
.ends

* Black-box entry subcircuit for sky130_ef_sc_hd__decap_12 abstract view
.subckt sky130_ef_sc_hd__decap_12 VPWR VGND VPB VNB
.ends

* Black-box entry subcircuit for sky130_fd_sc_hd__decap_4 abstract view
.subckt sky130_fd_sc_hd__decap_4 VGND VNB VPB VPWR
.ends

* Black-box entry subcircuit for sky130_fd_sc_hd__nor2_1 abstract view
.subckt sky130_fd_sc_hd__nor2_1 A B VGND VNB VPB VPWR Y
.ends

* Black-box entry subcircuit for sky130_fd_sc_hd__fill_1 abstract view
.subckt sky130_fd_sc_hd__fill_1 VGND VNB VPB VPWR
.ends

* Black-box entry subcircuit for sky130_fd_sc_hd__fill_2 abstract view
.subckt sky130_fd_sc_hd__fill_2 VGND VNB VPB VPWR
.ends

* Black-box entry subcircuit for sky130_fd_sc_hd__a21oi_1 abstract view
.subckt sky130_fd_sc_hd__a21oi_1 A1 A2 B1 VGND VNB VPB VPWR Y
.ends

* Black-box entry subcircuit for sky130_fd_sc_hd__decap_8 abstract view
.subckt sky130_fd_sc_hd__decap_8 VGND VNB VPB VPWR
.ends

* Black-box entry subcircuit for sky130_fd_sc_hd__dlygate4sd1_1 abstract view
.subckt sky130_fd_sc_hd__dlygate4sd1_1 A VGND VNB VPB VPWR X
.ends

* Black-box entry subcircuit for sky130_fd_sc_hd__decap_3 abstract view
.subckt sky130_fd_sc_hd__decap_3 VGND VNB VPB VPWR
.ends

* Black-box entry subcircuit for sky130_fd_sc_hd__and3b_2 abstract view
.subckt sky130_fd_sc_hd__and3b_2 A_N B C VGND VNB VPB VPWR X
.ends

* Black-box entry subcircuit for sky130_fd_sc_hd__o2bb2a_2 abstract view
.subckt sky130_fd_sc_hd__o2bb2a_2 A1_N A2_N B1 B2 VGND VNB VPB VPWR X
.ends

* Black-box entry subcircuit for sky130_fd_sc_hd__a21bo_1 abstract view
.subckt sky130_fd_sc_hd__a21bo_1 A1 A2 B1_N VGND VNB VPB VPWR X
.ends

* Black-box entry subcircuit for sky130_fd_sc_hd__and2b_1 abstract view
.subckt sky130_fd_sc_hd__and2b_1 A_N B VGND VNB VPB VPWR X
.ends

* Black-box entry subcircuit for sky130_fd_sc_hd__dfrtp_1 abstract view
.subckt sky130_fd_sc_hd__dfrtp_1 CLK D RESET_B VGND VNB VPB VPWR Q
.ends

* Black-box entry subcircuit for sky130_fd_sc_hd__xor2_1 abstract view
.subckt sky130_fd_sc_hd__xor2_1 A B VGND VNB VPB VPWR X
.ends

* Black-box entry subcircuit for sky130_fd_sc_hd__buf_2 abstract view
.subckt sky130_fd_sc_hd__buf_2 A VGND VNB VPB VPWR X
.ends

* Black-box entry subcircuit for sky130_fd_sc_hd__and2_1 abstract view
.subckt sky130_fd_sc_hd__and2_1 A B VGND VNB VPB VPWR X
.ends

* Black-box entry subcircuit for sky130_fd_sc_hd__clkbuf_1 abstract view
.subckt sky130_fd_sc_hd__clkbuf_1 A VGND VNB VPB VPWR X
.ends

* Black-box entry subcircuit for sky130_fd_sc_hd__a31o_1 abstract view
.subckt sky130_fd_sc_hd__a31o_1 A1 A2 A3 B1 VGND VNB VPB VPWR X
.ends

* Black-box entry subcircuit for sky130_fd_sc_hd__o21bai_1 abstract view
.subckt sky130_fd_sc_hd__o21bai_1 A1 A2 B1_N VGND VNB VPB VPWR Y
.ends

* Black-box entry subcircuit for sky130_fd_sc_hd__mux2_1 abstract view
.subckt sky130_fd_sc_hd__mux2_1 A0 A1 S VGND VNB VPB VPWR X
.ends

* Black-box entry subcircuit for sky130_fd_sc_hd__dlymetal6s2s_1 abstract view
.subckt sky130_fd_sc_hd__dlymetal6s2s_1 A VGND VNB VPB VPWR X
.ends

* Black-box entry subcircuit for sky130_fd_sc_hd__xnor2_2 abstract view
.subckt sky130_fd_sc_hd__xnor2_2 A B VGND VNB VPB VPWR Y
.ends

* Black-box entry subcircuit for sky130_fd_sc_hd__o22a_1 abstract view
.subckt sky130_fd_sc_hd__o22a_1 A1 A2 B1 B2 VGND VNB VPB VPWR X
.ends

* Black-box entry subcircuit for sky130_fd_sc_hd__nand3_1 abstract view
.subckt sky130_fd_sc_hd__nand3_1 A B C VGND VNB VPB VPWR Y
.ends

* Black-box entry subcircuit for sky130_fd_sc_hd__o211a_1 abstract view
.subckt sky130_fd_sc_hd__o211a_1 A1 A2 B1 C1 VGND VNB VPB VPWR X
.ends

* Black-box entry subcircuit for sky130_fd_sc_hd__a22o_1 abstract view
.subckt sky130_fd_sc_hd__a22o_1 A1 A2 B1 B2 VGND VNB VPB VPWR X
.ends

* Black-box entry subcircuit for sky130_fd_sc_hd__or2_1 abstract view
.subckt sky130_fd_sc_hd__or2_1 A B VGND VNB VPB VPWR X
.ends

* Black-box entry subcircuit for sky130_fd_sc_hd__xnor2_1 abstract view
.subckt sky130_fd_sc_hd__xnor2_1 A B VGND VNB VPB VPWR Y
.ends

* Black-box entry subcircuit for sky130_fd_sc_hd__and4bb_1 abstract view
.subckt sky130_fd_sc_hd__and4bb_1 A_N B_N C D VGND VNB VPB VPWR X
.ends

* Black-box entry subcircuit for sky130_fd_sc_hd__and3_1 abstract view
.subckt sky130_fd_sc_hd__and3_1 A B C VGND VNB VPB VPWR X
.ends

* Black-box entry subcircuit for sky130_fd_sc_hd__nand2_1 abstract view
.subckt sky130_fd_sc_hd__nand2_1 A B VGND VNB VPB VPWR Y
.ends

* Black-box entry subcircuit for sky130_fd_sc_hd__dlygate4sd3_1 abstract view
.subckt sky130_fd_sc_hd__dlygate4sd3_1 A VGND VNB VPB VPWR X
.ends

* Black-box entry subcircuit for sky130_fd_sc_hd__o211ai_1 abstract view
.subckt sky130_fd_sc_hd__o211ai_1 A1 A2 B1 C1 VGND VNB VPB VPWR Y
.ends

* Black-box entry subcircuit for sky130_fd_sc_hd__clkbuf_4 abstract view
.subckt sky130_fd_sc_hd__clkbuf_4 A VGND VNB VPB VPWR X
.ends

* Black-box entry subcircuit for sky130_fd_sc_hd__dfrtp_4 abstract view
.subckt sky130_fd_sc_hd__dfrtp_4 CLK D RESET_B VGND VNB VPB VPWR Q
.ends

* Black-box entry subcircuit for sky130_fd_sc_hd__nand4_1 abstract view
.subckt sky130_fd_sc_hd__nand4_1 A B C D VGND VNB VPB VPWR Y
.ends

* Black-box entry subcircuit for sky130_fd_sc_hd__nand3_2 abstract view
.subckt sky130_fd_sc_hd__nand3_2 A B C VGND VNB VPB VPWR Y
.ends

* Black-box entry subcircuit for sky130_fd_sc_hd__a2bb2o_1 abstract view
.subckt sky130_fd_sc_hd__a2bb2o_1 A1_N A2_N B1 B2 VGND VNB VPB VPWR X
.ends

* Black-box entry subcircuit for sky130_fd_sc_hd__clkbuf_16 abstract view
.subckt sky130_fd_sc_hd__clkbuf_16 A VGND VNB VPB VPWR X
.ends

* Black-box entry subcircuit for sky130_fd_sc_hd__a311oi_1 abstract view
.subckt sky130_fd_sc_hd__a311oi_1 A1 A2 A3 B1 C1 VGND VNB VPB VPWR Y
.ends

* Black-box entry subcircuit for sky130_fd_sc_hd__and3b_1 abstract view
.subckt sky130_fd_sc_hd__and3b_1 A_N B C VGND VNB VPB VPWR X
.ends

* Black-box entry subcircuit for sky130_fd_sc_hd__and4_1 abstract view
.subckt sky130_fd_sc_hd__and4_1 A B C D VGND VNB VPB VPWR X
.ends

* Black-box entry subcircuit for sky130_fd_sc_hd__a221o_1 abstract view
.subckt sky130_fd_sc_hd__a221o_1 A1 A2 B1 B2 C1 VGND VNB VPB VPWR X
.ends

* Black-box entry subcircuit for sky130_fd_sc_hd__nor2_4 abstract view
.subckt sky130_fd_sc_hd__nor2_4 A B VGND VNB VPB VPWR Y
.ends

* Black-box entry subcircuit for sky130_fd_sc_hd__buf_6 abstract view
.subckt sky130_fd_sc_hd__buf_6 A VGND VNB VPB VPWR X
.ends

* Black-box entry subcircuit for sky130_fd_sc_hd__a211oi_2 abstract view
.subckt sky130_fd_sc_hd__a211oi_2 A1 A2 B1 C1 VGND VNB VPB VPWR Y
.ends

* Black-box entry subcircuit for sky130_fd_sc_hd__nand4_2 abstract view
.subckt sky130_fd_sc_hd__nand4_2 A B C D VGND VNB VPB VPWR Y
.ends

* Black-box entry subcircuit for sky130_fd_sc_hd__dfrtp_2 abstract view
.subckt sky130_fd_sc_hd__dfrtp_2 CLK D RESET_B VGND VNB VPB VPWR Q
.ends

* Black-box entry subcircuit for sky130_fd_sc_hd__o211ai_2 abstract view
.subckt sky130_fd_sc_hd__o211ai_2 A1 A2 B1 C1 VGND VNB VPB VPWR Y
.ends

* Black-box entry subcircuit for sky130_fd_sc_hd__o21a_1 abstract view
.subckt sky130_fd_sc_hd__o21a_1 A1 A2 B1 VGND VNB VPB VPWR X
.ends

* Black-box entry subcircuit for sky130_fd_sc_hd__or3_1 abstract view
.subckt sky130_fd_sc_hd__or3_1 A B C VGND VNB VPB VPWR X
.ends

* Black-box entry subcircuit for sky130_fd_sc_hd__or4_4 abstract view
.subckt sky130_fd_sc_hd__or4_4 A B C D VGND VNB VPB VPWR X
.ends

* Black-box entry subcircuit for sky130_fd_sc_hd__o21ba_1 abstract view
.subckt sky130_fd_sc_hd__o21ba_1 A1 A2 B1_N VGND VNB VPB VPWR X
.ends

* Black-box entry subcircuit for sky130_fd_sc_hd__a22oi_2 abstract view
.subckt sky130_fd_sc_hd__a22oi_2 A1 A2 B1 B2 VGND VNB VPB VPWR Y
.ends

* Black-box entry subcircuit for sky130_fd_sc_hd__a31oi_2 abstract view
.subckt sky130_fd_sc_hd__a31oi_2 A1 A2 A3 B1 VGND VNB VPB VPWR Y
.ends

* Black-box entry subcircuit for sky130_fd_sc_hd__o21a_2 abstract view
.subckt sky130_fd_sc_hd__o21a_2 A1 A2 B1 VGND VNB VPB VPWR X
.ends

* Black-box entry subcircuit for sky130_fd_sc_hd__o2bb2a_1 abstract view
.subckt sky130_fd_sc_hd__o2bb2a_1 A1_N A2_N B1 B2 VGND VNB VPB VPWR X
.ends

* Black-box entry subcircuit for sky130_fd_sc_hd__a22oi_1 abstract view
.subckt sky130_fd_sc_hd__a22oi_1 A1 A2 B1 B2 VGND VNB VPB VPWR Y
.ends

* Black-box entry subcircuit for sky130_fd_sc_hd__a211o_1 abstract view
.subckt sky130_fd_sc_hd__a211o_1 A1 A2 B1 C1 VGND VNB VPB VPWR X
.ends

* Black-box entry subcircuit for sky130_fd_sc_hd__and2_4 abstract view
.subckt sky130_fd_sc_hd__and2_4 A B VGND VNB VPB VPWR X
.ends

* Black-box entry subcircuit for sky130_fd_sc_hd__a211oi_4 abstract view
.subckt sky130_fd_sc_hd__a211oi_4 A1 A2 B1 C1 VGND VNB VPB VPWR Y
.ends

* Black-box entry subcircuit for sky130_fd_sc_hd__a32o_1 abstract view
.subckt sky130_fd_sc_hd__a32o_1 A1 A2 A3 B1 B2 VGND VNB VPB VPWR X
.ends

* Black-box entry subcircuit for sky130_fd_sc_hd__buf_1 abstract view
.subckt sky130_fd_sc_hd__buf_1 A VGND VNB VPB VPWR X
.ends

* Black-box entry subcircuit for sky130_fd_sc_hd__o21ai_1 abstract view
.subckt sky130_fd_sc_hd__o21ai_1 A1 A2 B1 VGND VNB VPB VPWR Y
.ends

* Black-box entry subcircuit for sky130_fd_sc_hd__a22oi_4 abstract view
.subckt sky130_fd_sc_hd__a22oi_4 A1 A2 B1 B2 VGND VNB VPB VPWR Y
.ends

* Black-box entry subcircuit for sky130_fd_sc_hd__nor3_1 abstract view
.subckt sky130_fd_sc_hd__nor3_1 A B C VGND VNB VPB VPWR Y
.ends

* Black-box entry subcircuit for sky130_fd_sc_hd__o21ai_2 abstract view
.subckt sky130_fd_sc_hd__o21ai_2 A1 A2 B1 VGND VNB VPB VPWR Y
.ends

* Black-box entry subcircuit for sky130_fd_sc_hd__a211o_4 abstract view
.subckt sky130_fd_sc_hd__a211o_4 A1 A2 B1 C1 VGND VNB VPB VPWR X
.ends

* Black-box entry subcircuit for sky130_fd_sc_hd__or2b_1 abstract view
.subckt sky130_fd_sc_hd__or2b_1 A B_N VGND VNB VPB VPWR X
.ends

* Black-box entry subcircuit for sky130_fd_sc_hd__a22o_2 abstract view
.subckt sky130_fd_sc_hd__a22o_2 A1 A2 B1 B2 VGND VNB VPB VPWR X
.ends

* Black-box entry subcircuit for sky130_fd_sc_hd__o31a_4 abstract view
.subckt sky130_fd_sc_hd__o31a_4 A1 A2 A3 B1 VGND VNB VPB VPWR X
.ends

* Black-box entry subcircuit for sky130_fd_sc_hd__a21oi_2 abstract view
.subckt sky130_fd_sc_hd__a21oi_2 A1 A2 B1 VGND VNB VPB VPWR Y
.ends

* Black-box entry subcircuit for sky130_fd_sc_hd__o221a_1 abstract view
.subckt sky130_fd_sc_hd__o221a_1 A1 A2 B1 B2 C1 VGND VNB VPB VPWR X
.ends

* Black-box entry subcircuit for sky130_fd_sc_hd__inv_2 abstract view
.subckt sky130_fd_sc_hd__inv_2 A VGND VNB VPB VPWR Y
.ends

* Black-box entry subcircuit for sky130_fd_sc_hd__nand4_4 abstract view
.subckt sky130_fd_sc_hd__nand4_4 A B C D VGND VNB VPB VPWR Y
.ends

* Black-box entry subcircuit for sky130_fd_sc_hd__o31a_1 abstract view
.subckt sky130_fd_sc_hd__o31a_1 A1 A2 A3 B1 VGND VNB VPB VPWR X
.ends

* Black-box entry subcircuit for sky130_fd_sc_hd__and3_4 abstract view
.subckt sky130_fd_sc_hd__and3_4 A B C VGND VNB VPB VPWR X
.ends

* Black-box entry subcircuit for sky130_fd_sc_hd__o311a_1 abstract view
.subckt sky130_fd_sc_hd__o311a_1 A1 A2 A3 B1 C1 VGND VNB VPB VPWR X
.ends

* Black-box entry subcircuit for sky130_fd_sc_hd__a311o_1 abstract view
.subckt sky130_fd_sc_hd__a311o_1 A1 A2 A3 B1 C1 VGND VNB VPB VPWR X
.ends

* Black-box entry subcircuit for sky130_fd_sc_hd__nand2_2 abstract view
.subckt sky130_fd_sc_hd__nand2_2 A B VGND VNB VPB VPWR Y
.ends

* Black-box entry subcircuit for sky130_fd_sc_hd__or3_4 abstract view
.subckt sky130_fd_sc_hd__or3_4 A B C VGND VNB VPB VPWR X
.ends

* Black-box entry subcircuit for sky130_fd_sc_hd__nor2_2 abstract view
.subckt sky130_fd_sc_hd__nor2_2 A B VGND VNB VPB VPWR Y
.ends

* Black-box entry subcircuit for sky130_fd_sc_hd__or2_4 abstract view
.subckt sky130_fd_sc_hd__or2_4 A B VGND VNB VPB VPWR X
.ends

* Black-box entry subcircuit for sky130_fd_sc_hd__nor3_2 abstract view
.subckt sky130_fd_sc_hd__nor3_2 A B C VGND VNB VPB VPWR Y
.ends

* Black-box entry subcircuit for sky130_fd_sc_hd__buf_4 abstract view
.subckt sky130_fd_sc_hd__buf_4 A VGND VNB VPB VPWR X
.ends

* Black-box entry subcircuit for sky130_fd_sc_hd__o211ai_4 abstract view
.subckt sky130_fd_sc_hd__o211ai_4 A1 A2 B1 C1 VGND VNB VPB VPWR Y
.ends

* Black-box entry subcircuit for sky130_fd_sc_hd__and4_2 abstract view
.subckt sky130_fd_sc_hd__and4_2 A B C D VGND VNB VPB VPWR X
.ends

* Black-box entry subcircuit for sky130_fd_sc_hd__mux2_4 abstract view
.subckt sky130_fd_sc_hd__mux2_4 A0 A1 S VGND VNB VPB VPWR X
.ends

* Black-box entry subcircuit for sky130_fd_sc_hd__or2_2 abstract view
.subckt sky130_fd_sc_hd__or2_2 A B VGND VNB VPB VPWR X
.ends

* Black-box entry subcircuit for sky130_fd_sc_hd__or4_1 abstract view
.subckt sky130_fd_sc_hd__or4_1 A B C D VGND VNB VPB VPWR X
.ends

* Black-box entry subcircuit for sky130_fd_sc_hd__or3b_1 abstract view
.subckt sky130_fd_sc_hd__or3b_1 A B C_N VGND VNB VPB VPWR X
.ends

* Black-box entry subcircuit for sky130_fd_sc_hd__o221ai_1 abstract view
.subckt sky130_fd_sc_hd__o221ai_1 A1 A2 B1 B2 C1 VGND VNB VPB VPWR Y
.ends

* Black-box entry subcircuit for sky130_fd_sc_hd__xor2_2 abstract view
.subckt sky130_fd_sc_hd__xor2_2 A B VGND VNB VPB VPWR X
.ends

* Black-box entry subcircuit for sky130_fd_sc_hd__a21boi_2 abstract view
.subckt sky130_fd_sc_hd__a21boi_2 A1 A2 B1_N VGND VNB VPB VPWR Y
.ends

* Black-box entry subcircuit for sky130_fd_sc_hd__a211o_2 abstract view
.subckt sky130_fd_sc_hd__a211o_2 A1 A2 B1 C1 VGND VNB VPB VPWR X
.ends

* Black-box entry subcircuit for sky130_fd_sc_hd__or3_2 abstract view
.subckt sky130_fd_sc_hd__or3_2 A B C VGND VNB VPB VPWR X
.ends

* Black-box entry subcircuit for sky130_fd_sc_hd__or3b_4 abstract view
.subckt sky130_fd_sc_hd__or3b_4 A B C_N VGND VNB VPB VPWR X
.ends

* Black-box entry subcircuit for sky130_fd_sc_hd__o41a_1 abstract view
.subckt sky130_fd_sc_hd__o41a_1 A1 A2 A3 A4 B1 VGND VNB VPB VPWR X
.ends

* Black-box entry subcircuit for sky130_fd_sc_hd__nand3_4 abstract view
.subckt sky130_fd_sc_hd__nand3_4 A B C VGND VNB VPB VPWR Y
.ends

* Black-box entry subcircuit for sky130_fd_sc_hd__nor3b_2 abstract view
.subckt sky130_fd_sc_hd__nor3b_2 A B C_N VGND VNB VPB VPWR Y
.ends

* Black-box entry subcircuit for sky130_fd_sc_hd__a311oi_2 abstract view
.subckt sky130_fd_sc_hd__a311oi_2 A1 A2 A3 B1 C1 VGND VNB VPB VPWR Y
.ends

* Black-box entry subcircuit for sky130_fd_sc_hd__nand2_4 abstract view
.subckt sky130_fd_sc_hd__nand2_4 A B VGND VNB VPB VPWR Y
.ends

* Black-box entry subcircuit for sky130_fd_sc_hd__a31oi_1 abstract view
.subckt sky130_fd_sc_hd__a31oi_1 A1 A2 A3 B1 VGND VNB VPB VPWR Y
.ends

* Black-box entry subcircuit for sky130_fd_sc_hd__o211a_2 abstract view
.subckt sky130_fd_sc_hd__o211a_2 A1 A2 B1 C1 VGND VNB VPB VPWR X
.ends

* Black-box entry subcircuit for sky130_fd_sc_hd__nor4_4 abstract view
.subckt sky130_fd_sc_hd__nor4_4 A B C D VGND VNB VPB VPWR Y
.ends

* Black-box entry subcircuit for sky130_fd_sc_hd__xor2_4 abstract view
.subckt sky130_fd_sc_hd__xor2_4 A B VGND VNB VPB VPWR X
.ends

* Black-box entry subcircuit for sky130_fd_sc_hd__o311a_4 abstract view
.subckt sky130_fd_sc_hd__o311a_4 A1 A2 A3 B1 C1 VGND VNB VPB VPWR X
.ends

* Black-box entry subcircuit for sky130_fd_sc_hd__or2b_4 abstract view
.subckt sky130_fd_sc_hd__or2b_4 A B_N VGND VNB VPB VPWR X
.ends

* Black-box entry subcircuit for sky130_fd_sc_hd__o2bb2a_4 abstract view
.subckt sky130_fd_sc_hd__o2bb2a_4 A1_N A2_N B1 B2 VGND VNB VPB VPWR X
.ends

* Black-box entry subcircuit for sky130_fd_sc_hd__a211oi_1 abstract view
.subckt sky130_fd_sc_hd__a211oi_1 A1 A2 B1 C1 VGND VNB VPB VPWR Y
.ends

* Black-box entry subcircuit for sky130_fd_sc_hd__or3b_2 abstract view
.subckt sky130_fd_sc_hd__or3b_2 A B C_N VGND VNB VPB VPWR X
.ends

* Black-box entry subcircuit for sky130_fd_sc_hd__and3_2 abstract view
.subckt sky130_fd_sc_hd__and3_2 A B C VGND VNB VPB VPWR X
.ends

* Black-box entry subcircuit for sky130_fd_sc_hd__o31a_2 abstract view
.subckt sky130_fd_sc_hd__o31a_2 A1 A2 A3 B1 VGND VNB VPB VPWR X
.ends

* Black-box entry subcircuit for sky130_fd_sc_hd__a32o_2 abstract view
.subckt sky130_fd_sc_hd__a32o_2 A1 A2 A3 B1 B2 VGND VNB VPB VPWR X
.ends

* Black-box entry subcircuit for sky130_fd_sc_hd__nor3_4 abstract view
.subckt sky130_fd_sc_hd__nor3_4 A B C VGND VNB VPB VPWR Y
.ends

* Black-box entry subcircuit for sky130_fd_sc_hd__o22ai_1 abstract view
.subckt sky130_fd_sc_hd__o22ai_1 A1 A2 B1 B2 VGND VNB VPB VPWR Y
.ends

* Black-box entry subcircuit for sky130_fd_sc_hd__o31ai_1 abstract view
.subckt sky130_fd_sc_hd__o31ai_1 A1 A2 A3 B1 VGND VNB VPB VPWR Y
.ends

* Black-box entry subcircuit for sky130_fd_sc_hd__o211a_4 abstract view
.subckt sky130_fd_sc_hd__o211a_4 A1 A2 B1 C1 VGND VNB VPB VPWR X
.ends

* Black-box entry subcircuit for sky130_fd_sc_hd__buf_12 abstract view
.subckt sky130_fd_sc_hd__buf_12 A VGND VNB VPB VPWR X
.ends

* Black-box entry subcircuit for sky130_fd_sc_hd__nand3b_2 abstract view
.subckt sky130_fd_sc_hd__nand3b_2 A_N B C VGND VNB VPB VPWR Y
.ends

* Black-box entry subcircuit for sky130_fd_sc_hd__buf_8 abstract view
.subckt sky130_fd_sc_hd__buf_8 A VGND VNB VPB VPWR X
.ends

* Black-box entry subcircuit for sky130_fd_sc_hd__a21o_2 abstract view
.subckt sky130_fd_sc_hd__a21o_2 A1 A2 B1 VGND VNB VPB VPWR X
.ends

* Black-box entry subcircuit for sky130_fd_sc_hd__xnor2_4 abstract view
.subckt sky130_fd_sc_hd__xnor2_4 A B VGND VNB VPB VPWR Y
.ends

* Black-box entry subcircuit for sky130_fd_sc_hd__dlygate4sd2_1 abstract view
.subckt sky130_fd_sc_hd__dlygate4sd2_1 A VGND VNB VPB VPWR X
.ends

* Black-box entry subcircuit for sky130_fd_sc_hd__and4b_1 abstract view
.subckt sky130_fd_sc_hd__and4b_1 A_N B C D VGND VNB VPB VPWR X
.ends

* Black-box entry subcircuit for sky130_fd_sc_hd__o31ai_2 abstract view
.subckt sky130_fd_sc_hd__o31ai_2 A1 A2 A3 B1 VGND VNB VPB VPWR Y
.ends

* Black-box entry subcircuit for sky130_fd_sc_hd__o22a_2 abstract view
.subckt sky130_fd_sc_hd__o22a_2 A1 A2 B1 B2 VGND VNB VPB VPWR X
.ends

* Black-box entry subcircuit for sky130_fd_sc_hd__a21boi_1 abstract view
.subckt sky130_fd_sc_hd__a21boi_1 A1 A2 B1_N VGND VNB VPB VPWR Y
.ends

* Black-box entry subcircuit for sky130_fd_sc_hd__a22o_4 abstract view
.subckt sky130_fd_sc_hd__a22o_4 A1 A2 B1 B2 VGND VNB VPB VPWR X
.ends

* Black-box entry subcircuit for sky130_fd_sc_hd__clkdlybuf4s15_2 abstract view
.subckt sky130_fd_sc_hd__clkdlybuf4s15_2 A VGND VNB VPB VPWR X
.ends

* Black-box entry subcircuit for sky130_fd_sc_hd__or4bb_4 abstract view
.subckt sky130_fd_sc_hd__or4bb_4 A B C_N D_N VGND VNB VPB VPWR X
.ends

* Black-box entry subcircuit for sky130_fd_sc_hd__a41o_1 abstract view
.subckt sky130_fd_sc_hd__a41o_1 A1 A2 A3 A4 B1 VGND VNB VPB VPWR X
.ends

* Black-box entry subcircuit for sky130_fd_sc_hd__nor4_2 abstract view
.subckt sky130_fd_sc_hd__nor4_2 A B C D VGND VNB VPB VPWR Y
.ends

* Black-box entry subcircuit for sky130_fd_sc_hd__o311ai_2 abstract view
.subckt sky130_fd_sc_hd__o311ai_2 A1 A2 A3 B1 C1 VGND VNB VPB VPWR Y
.ends

.subckt mac_16bit VGND VPWR clk clr en in_a[0] in_a[10] in_a[11] in_a[12] in_a[13]
+ in_a[14] in_a[15] in_a[1] in_a[2] in_a[3] in_a[4] in_a[5] in_a[6] in_a[7] in_a[8]
+ in_a[9] in_b[0] in_b[10] in_b[11] in_b[12] in_b[13] in_b[14] in_b[15] in_b[1] in_b[2]
+ in_b[3] in_b[4] in_b[5] in_b[6] in_b[7] in_b[8] in_b[9] out_acc[0] out_acc[10] out_acc[11]
+ out_acc[12] out_acc[13] out_acc[14] out_acc[15] out_acc[16] out_acc[17] out_acc[18]
+ out_acc[19] out_acc[1] out_acc[20] out_acc[21] out_acc[22] out_acc[23] out_acc[24]
+ out_acc[25] out_acc[26] out_acc[27] out_acc[28] out_acc[29] out_acc[2] out_acc[30]
+ out_acc[31] out_acc[32] out_acc[33] out_acc[34] out_acc[35] out_acc[3] out_acc[4]
+ out_acc[5] out_acc[6] out_acc[7] out_acc[8] out_acc[9] ovf rst_n valid_out
XTAP_177 VGND VPWR sky130_fd_sc_hd__tapvpwrvgnd_1
XTAP_188 VGND VPWR sky130_fd_sc_hd__tapvpwrvgnd_1
XTAP_199 VGND VPWR sky130_fd_sc_hd__tapvpwrvgnd_1
X_3155_ net6 VGND VGND VPWR VPWR _0270_ sky130_fd_sc_hd__clkbuf_2
X_3086_ _0198_ _0199_ _0200_ VGND VGND VPWR VPWR _0202_ sky130_fd_sc_hd__a21o_1
XFILLER_0_76_133 VGND VGND VPWR VPWR sky130_fd_sc_hd__decap_6
XFILLER_0_76_166 VPWR VGND VPWR VGND sky130_ef_sc_hd__decap_12
XFILLER_0_43_81 VGND VGND VPWR VPWR sky130_fd_sc_hd__decap_4
X_3988_ _1111_ _1118_ VGND VGND VPWR VPWR _1120_ sky130_fd_sc_hd__nor2_1
XFILLER_0_17_211 VGND VGND VPWR VPWR sky130_fd_sc_hd__fill_1
XFILLER_0_57_380 VGND VGND VPWR VPWR sky130_fd_sc_hd__fill_2
XFILLER_0_57_391 VGND VGND VPWR VPWR sky130_fd_sc_hd__fill_1
XFILLER_0_64_328 VGND VGND VPWR VPWR sky130_fd_sc_hd__decap_6
X_2939_ _2111_ _2112_ _2071_ VGND VGND VPWR VPWR _2114_ sky130_fd_sc_hd__a21oi_1
XFILLER_0_32_214 VGND VGND VPWR VPWR sky130_fd_sc_hd__fill_1
XFILLER_0_13_461 VGND VGND VPWR VPWR sky130_fd_sc_hd__fill_2
XFILLER_0_67_100 VPWR VGND VPWR VGND sky130_ef_sc_hd__decap_12
XFILLER_0_67_122 VPWR VGND VPWR VGND sky130_ef_sc_hd__decap_12
XFILLER_0_23_214 VGND VGND VPWR VPWR sky130_fd_sc_hd__decap_8
XFILLER_0_23_225 VPWR VGND VPWR VGND sky130_ef_sc_hd__decap_12
Xrebuffer7 _0798_ VGND VGND VPWR VPWR net80 sky130_fd_sc_hd__dlygate4sd1_1
XFILLER_0_3_39 VPWR VGND VPWR VGND sky130_ef_sc_hd__decap_12
X_3911_ _1034_ _1036_ VGND VGND VPWR VPWR _1037_ sky130_fd_sc_hd__nor2_1
X_3842_ _0291_ _0402_ VGND VGND VPWR VPWR _0963_ sky130_fd_sc_hd__nor2_1
XFILLER_0_39_391 VGND VGND VPWR VPWR sky130_fd_sc_hd__fill_1
XFILLER_0_73_169 VGND VGND VPWR VPWR sky130_fd_sc_hd__decap_3
X_3773_ _0561_ _0517_ _0766_ VGND VGND VPWR VPWR _0888_ sky130_fd_sc_hd__and3b_2
X_2724_ _1660_ _1895_ _1899_ _1901_ VGND VGND VPWR VPWR _1902_ sky130_fd_sc_hd__o2bb2a_2
XFILLER_0_14_269 VPWR VGND VPWR VGND sky130_ef_sc_hd__decap_12
X_2655_ _1776_ _1773_ _1775_ VGND VGND VPWR VPWR _1834_ sky130_fd_sc_hd__a21bo_1
XFILLER_0_10_453 VGND VGND VPWR VPWR sky130_fd_sc_hd__decap_8
X_2586_ _1766_ _1765_ VGND VGND VPWR VPWR _1767_ sky130_fd_sc_hd__and2b_1
X_4325_ clknet_3_7__leaf_clk net2 net35 VGND VGND VPWR VPWR en_delay sky130_fd_sc_hd__dfrtp_1
X_4256_ clknet_3_1__leaf_clk _0000_ net35 VGND VGND VPWR VPWR net72 sky130_fd_sc_hd__dfrtp_1
XFILLER_0_38_81 VGND VGND VPWR VPWR sky130_fd_sc_hd__decap_3
X_4187_ _1283_ _1334_ VGND VGND VPWR VPWR _1335_ sky130_fd_sc_hd__xor2_1
X_3207_ _1654_ VGND VGND VPWR VPWR _0321_ sky130_fd_sc_hd__buf_2
X_3138_ _0249_ _0251_ _0252_ VGND VGND VPWR VPWR _0253_ sky130_fd_sc_hd__a21bo_1
X_3069_ _1934_ _2094_ VGND VGND VPWR VPWR _0185_ sky130_fd_sc_hd__and2_1
XFILLER_0_52_309 VGND VGND VPWR VPWR sky130_fd_sc_hd__decap_6
XFILLER_0_45_372 VGND VGND VPWR VPWR sky130_fd_sc_hd__decap_4
XFILLER_0_3_417 VPWR VGND VPWR VGND sky130_ef_sc_hd__decap_12
X_2440_ _1631_ VGND VGND VPWR VPWR _0032_ sky130_fd_sc_hd__clkbuf_1
XFILLER_0_59_36 VPWR VGND VPWR VGND sky130_ef_sc_hd__decap_12
X_2371_ _0875_ _1571_ _1406_ _1404_ VGND VGND VPWR VPWR _1575_ sky130_fd_sc_hd__a31o_1
X_4110_ _1184_ _1203_ _1183_ VGND VGND VPWR VPWR _1252_ sky130_fd_sc_hd__o21bai_1
XFILLER_0_75_57 VPWR VGND VPWR VGND sky130_ef_sc_hd__decap_12
X_4041_ add_tmp\[25\] _1177_ _1054_ VGND VGND VPWR VPWR _1178_ sky130_fd_sc_hd__mux2_1
XFILLER_0_24_83 VGND VGND VPWR VPWR sky130_fd_sc_hd__fill_1
XFILLER_0_74_445 VPWR VGND VPWR VGND sky130_ef_sc_hd__decap_12
XFILLER_0_46_147 VGND VGND VPWR VPWR sky130_fd_sc_hd__decap_8
X_3825_ _0936_ _0942_ _0856_ VGND VGND VPWR VPWR _0944_ sky130_fd_sc_hd__a21o_1
XFILLER_0_6_244 VGND VGND VPWR VPWR sky130_fd_sc_hd__decap_8
XFILLER_0_34_309 VGND VGND VPWR VPWR sky130_fd_sc_hd__decap_6
XFILLER_0_61_117 VGND VGND VPWR VPWR sky130_fd_sc_hd__fill_1
XFILLER_0_6_277 VGND VGND VPWR VPWR sky130_fd_sc_hd__fill_2
X_3756_ _0868_ VGND VGND VPWR VPWR _0869_ sky130_fd_sc_hd__dlymetal6s2s_1
XFILLER_0_40_60 VGND VGND VPWR VPWR sky130_fd_sc_hd__fill_1
X_2707_ _1878_ _1884_ VGND VGND VPWR VPWR _1885_ sky130_fd_sc_hd__xnor2_2
X_3687_ _0787_ _0788_ _0794_ _0795_ VGND VGND VPWR VPWR _0796_ sky130_fd_sc_hd__o22a_1
X_2638_ _1816_ VGND VGND VPWR VPWR _1817_ sky130_fd_sc_hd__buf_2
X_2569_ _1747_ _1748_ _1749_ VGND VGND VPWR VPWR _1750_ sky130_fd_sc_hd__nand3_1
X_4308_ clknet_3_4__leaf_clk _0053_ net35 VGND VGND VPWR VPWR add_tmp\[15\] sky130_fd_sc_hd__dfrtp_1
X_4239_ add_tmp\[30\] _1390_ _1054_ VGND VGND VPWR VPWR _1391_ sky130_fd_sc_hd__mux2_1
XFILLER_0_4_82 VGND VGND VPWR VPWR sky130_fd_sc_hd__fill_2
XFILLER_0_77_261 VGND VGND VPWR VPWR sky130_fd_sc_hd__fill_1
XFILLER_0_65_423 VPWR VGND VPWR VGND sky130_ef_sc_hd__decap_12
XFILLER_0_33_331 VGND VGND VPWR VPWR sky130_fd_sc_hd__decap_4
XFILLER_0_52_128 VPWR VGND VPWR VGND sky130_ef_sc_hd__decap_12
XFILLER_0_60_172 VPWR VGND VPWR VGND sky130_ef_sc_hd__decap_12
XFILLER_0_0_29 VGND VGND VPWR VPWR sky130_fd_sc_hd__decap_8
XFILLER_0_68_261 VGND VGND VPWR VPWR sky130_fd_sc_hd__decap_3
XFILLER_0_9_27 VPWR VGND VPWR VGND sky130_ef_sc_hd__decap_12
X_3610_ _0648_ _0650_ VGND VGND VPWR VPWR _0720_ sky130_fd_sc_hd__nor2_1
X_3541_ _0638_ _0651_ VGND VGND VPWR VPWR _0652_ sky130_fd_sc_hd__xnor2_2
XFILLER_0_10_85 VGND VGND VPWR VPWR sky130_fd_sc_hd__decap_4
X_3472_ _0581_ _0582_ _0457_ _0487_ VGND VGND VPWR VPWR _0584_ sky130_fd_sc_hd__o211a_1
X_2423_ net55 _1501_ _1503_ add_tmp\[27\] VGND VGND VPWR VPWR _1618_ sky130_fd_sc_hd__a22o_1
X_2354_ net41 _1561_ _1553_ VGND VGND VPWR VPWR _1562_ sky130_fd_sc_hd__mux2_1
X_2285_ net58 add_tmp\[2\] VGND VGND VPWR VPWR _1505_ sky130_fd_sc_hd__or2_1
X_4024_ _0837_ _0746_ _1062_ _1063_ VGND VGND VPWR VPWR _1160_ sky130_fd_sc_hd__a31o_1
XFILLER_0_66_209 VPWR VGND VPWR VGND sky130_ef_sc_hd__decap_12
X_3808_ _0923_ _0924_ VGND VGND VPWR VPWR _0925_ sky130_fd_sc_hd__xnor2_1
X_3739_ _0847_ _0848_ _0833_ VGND VGND VPWR VPWR _0850_ sky130_fd_sc_hd__a21o_1
XFILLER_0_30_312 VPWR VGND VPWR VGND sky130_ef_sc_hd__decap_12
XFILLER_0_30_356 VGND VGND VPWR VPWR sky130_fd_sc_hd__fill_1
XFILLER_0_38_412 VGND VGND VPWR VPWR sky130_fd_sc_hd__fill_1
XFILLER_0_0_217 VGND VGND VPWR VPWR sky130_fd_sc_hd__decap_6
XTAP_507 VGND VPWR sky130_fd_sc_hd__tapvpwrvgnd_1
XTAP_518 VGND VPWR sky130_fd_sc_hd__tapvpwrvgnd_1
XTAP_529 VGND VPWR sky130_fd_sc_hd__tapvpwrvgnd_1
XFILLER_0_72_69 VGND VGND VPWR VPWR sky130_fd_sc_hd__fill_1
XFILLER_0_8_306 VGND VGND VPWR VPWR sky130_fd_sc_hd__fill_2
XFILLER_0_29_445 VGND VGND VPWR VPWR sky130_fd_sc_hd__decap_3
X_2972_ _0084_ _0086_ _1701_ _0088_ VGND VGND VPWR VPWR _0089_ sky130_fd_sc_hd__and4bb_1
XFILLER_0_56_231 VGND VGND VPWR VPWR sky130_fd_sc_hd__fill_1
XFILLER_0_56_253 VPWR VGND VPWR VGND sky130_ef_sc_hd__decap_12
XFILLER_0_71_223 VGND VGND VPWR VPWR sky130_fd_sc_hd__fill_1
X_3524_ _0628_ _0632_ _0634_ VGND VGND VPWR VPWR _0635_ sky130_fd_sc_hd__and3_1
X_3455_ _0564_ _0565_ _0566_ VGND VGND VPWR VPWR _0567_ sky130_fd_sc_hd__nand3_1
X_2406_ _1451_ _1603_ VGND VGND VPWR VPWR _1604_ sky130_fd_sc_hd__xnor2_1
X_3386_ _0488_ _0489_ _0498_ VGND VGND VPWR VPWR _0499_ sky130_fd_sc_hd__a21bo_1
X_2337_ _1546_ _1547_ VGND VGND VPWR VPWR _1548_ sky130_fd_sc_hd__xnor2_1
X_2268_ _1488_ net1 _1490_ VGND VGND VPWR VPWR _1491_ sky130_fd_sc_hd__mux2_1
X_4007_ _0328_ VGND VGND VPWR VPWR _1141_ sky130_fd_sc_hd__dlymetal6s2s_1
X_2199_ net51 add_tmp\[23\] VGND VGND VPWR VPWR _1423_ sky130_fd_sc_hd__nand2_1
XFILLER_0_7_361 VPWR VGND VPWR VGND sky130_ef_sc_hd__decap_12
XFILLER_0_62_245 VGND VGND VPWR VPWR sky130_fd_sc_hd__decap_6
XFILLER_0_62_289 VGND VGND VPWR VPWR sky130_fd_sc_hd__fill_1
Xhold63 add_tmp\[27\] VGND VGND VPWR VPWR net136 sky130_fd_sc_hd__dlygate4sd3_1
XFILLER_0_26_29 VGND VGND VPWR VPWR sky130_fd_sc_hd__decap_3
XTAP_315 VGND VPWR sky130_fd_sc_hd__tapvpwrvgnd_1
XTAP_304 VGND VPWR sky130_fd_sc_hd__tapvpwrvgnd_1
XTAP_326 VGND VPWR sky130_fd_sc_hd__tapvpwrvgnd_1
XTAP_337 VGND VPWR sky130_fd_sc_hd__tapvpwrvgnd_1
XTAP_348 VGND VPWR sky130_fd_sc_hd__tapvpwrvgnd_1
X_3240_ _2092_ VGND VGND VPWR VPWR _0354_ sky130_fd_sc_hd__clkbuf_2
XTAP_359 VGND VPWR sky130_fd_sc_hd__tapvpwrvgnd_1
X_3171_ _0197_ _0190_ _0189_ VGND VGND VPWR VPWR _0286_ sky130_fd_sc_hd__a21bo_1
Xrebuffer17 _1968_ VGND VGND VPWR VPWR net90 sky130_fd_sc_hd__clkbuf_1
Xrebuffer39 _2072_ VGND VGND VPWR VPWR net112 sky130_fd_sc_hd__clkbuf_1
Xrebuffer28 _0139_ VGND VGND VPWR VPWR net101 sky130_fd_sc_hd__clkbuf_1
XFILLER_0_29_253 VPWR VGND VPWR VGND sky130_ef_sc_hd__decap_12
XFILLER_0_17_415 VGND VGND VPWR VPWR sky130_fd_sc_hd__decap_3
X_2955_ _2050_ _2121_ _2125_ _2049_ VGND VGND VPWR VPWR _0072_ sky130_fd_sc_hd__o211ai_1
X_2886_ net21 VGND VGND VPWR VPWR _2061_ sky130_fd_sc_hd__buf_2
XFILLER_0_32_418 VGND VGND VPWR VPWR sky130_fd_sc_hd__fill_2
XFILLER_0_32_429 VGND VGND VPWR VPWR sky130_fd_sc_hd__decap_3
XFILLER_0_12_164 VPWR VGND VPWR VGND sky130_ef_sc_hd__decap_12
XFILLER_0_12_131 VGND VGND VPWR VPWR sky130_fd_sc_hd__decap_3
XFILLER_0_40_462 VGND VGND VPWR VPWR sky130_fd_sc_hd__fill_1
X_3507_ _0616_ _0617_ VGND VGND VPWR VPWR _0618_ sky130_fd_sc_hd__nor2_1
X_3438_ _0208_ _0277_ _0547_ _0548_ VGND VGND VPWR VPWR _0550_ sky130_fd_sc_hd__a22o_1
X_3369_ _0479_ _0480_ _0459_ VGND VGND VPWR VPWR _0482_ sky130_fd_sc_hd__a21oi_1
XFILLER_0_67_337 VPWR VGND VPWR VGND sky130_ef_sc_hd__decap_12
XFILLER_0_75_381 VGND VGND VPWR VPWR sky130_fd_sc_hd__decap_8
XFILLER_0_50_215 VPWR VGND VPWR VGND sky130_ef_sc_hd__decap_12
Xoutput42 net42 VGND VGND VPWR VPWR out_acc[15] sky130_fd_sc_hd__clkbuf_4
Xoutput64 net64 VGND VGND VPWR VPWR out_acc[35] sky130_fd_sc_hd__clkbuf_4
Xoutput53 net53 VGND VGND VPWR VPWR out_acc[25] sky130_fd_sc_hd__clkbuf_4
XFILLER_0_58_315 VGND VGND VPWR VPWR sky130_fd_sc_hd__decap_6
XFILLER_0_26_245 VGND VGND VPWR VPWR sky130_fd_sc_hd__decap_6
X_2740_ _1913_ _1914_ _1916_ VGND VGND VPWR VPWR _1918_ sky130_fd_sc_hd__a21o_1
X_2671_ _1847_ _1848_ _1849_ VGND VGND VPWR VPWR _1850_ sky130_fd_sc_hd__a21o_1
XFILLER_0_41_237 VGND VGND VPWR VPWR sky130_fd_sc_hd__decap_6
XFILLER_0_41_259 VGND VGND VPWR VPWR sky130_fd_sc_hd__decap_4
X_4272_ clknet_3_5__leaf_clk _0017_ net35 VGND VGND VPWR VPWR net42 sky130_fd_sc_hd__dfrtp_4
XTAP_156 VGND VPWR sky130_fd_sc_hd__tapvpwrvgnd_1
X_3223_ _0271_ _0266_ _0269_ VGND VGND VPWR VPWR _0337_ sky130_fd_sc_hd__a21bo_1
XTAP_167 VGND VPWR sky130_fd_sc_hd__tapvpwrvgnd_1
XTAP_178 VGND VPWR sky130_fd_sc_hd__tapvpwrvgnd_1
XTAP_189 VGND VPWR sky130_fd_sc_hd__tapvpwrvgnd_1
X_3154_ _0117_ _1937_ _0267_ _0268_ VGND VGND VPWR VPWR _0269_ sky130_fd_sc_hd__nand4_1
XFILLER_0_27_83 VGND VGND VPWR VPWR sky130_fd_sc_hd__fill_2
X_3085_ _0198_ _0199_ _0200_ VGND VGND VPWR VPWR _0201_ sky130_fd_sc_hd__nand3_2
XFILLER_0_49_337 VPWR VGND VPWR VGND sky130_ef_sc_hd__decap_12
XFILLER_0_76_178 VPWR VGND VPWR VGND sky130_ef_sc_hd__decap_12
X_3987_ _1118_ _1119_ add_tmp\[24\] _1712_ VGND VGND VPWR VPWR _0062_ sky130_fd_sc_hd__a2bb2o_1
XFILLER_0_17_223 VGND VGND VPWR VPWR sky130_fd_sc_hd__fill_1
X_2938_ _2071_ _2111_ _2112_ VGND VGND VPWR VPWR _2113_ sky130_fd_sc_hd__and3_1
X_2869_ _2043_ _2031_ _2032_ VGND VGND VPWR VPWR _2045_ sky130_fd_sc_hd__and3_1
XFILLER_0_72_395 VPWR VGND VPWR VGND sky130_ef_sc_hd__decap_12
XTAP_690 VGND VPWR sky130_fd_sc_hd__tapvpwrvgnd_1
Xclkbuf_3_6__f_clk clknet_0_clk VGND VGND VPWR VPWR clknet_3_6__leaf_clk sky130_fd_sc_hd__clkbuf_16
XFILLER_0_67_134 VPWR VGND VPWR VGND sky130_ef_sc_hd__decap_12
XFILLER_0_67_189 VPWR VGND VPWR VGND sky130_ef_sc_hd__decap_12
XFILLER_0_23_237 VGND VGND VPWR VPWR sky130_fd_sc_hd__decap_8
Xrebuffer8 _1907_ VGND VGND VPWR VPWR net81 sky130_fd_sc_hd__clkbuf_1
XFILLER_0_31_270 VGND VGND VPWR VPWR sky130_fd_sc_hd__fill_1
XFILLER_0_64_15 VGND VGND VPWR VPWR sky130_fd_sc_hd__decap_3
X_3910_ _0755_ _0520_ _0923_ _1035_ _0922_ VGND VGND VPWR VPWR _1036_ sky130_fd_sc_hd__a311oi_1
X_3841_ _0291_ _0517_ _0843_ VGND VGND VPWR VPWR _0961_ sky130_fd_sc_hd__and3b_1
X_3772_ _0753_ _0770_ _0771_ VGND VGND VPWR VPWR _0887_ sky130_fd_sc_hd__and3_1
X_2723_ _1666_ _1752_ _1900_ _1816_ VGND VGND VPWR VPWR _1901_ sky130_fd_sc_hd__and4_1
XFILLER_0_54_362 VGND VGND VPWR VPWR sky130_fd_sc_hd__fill_2
X_2654_ _1828_ _1831_ _1826_ VGND VGND VPWR VPWR _1833_ sky130_fd_sc_hd__a21o_1
X_2585_ _1762_ _1763_ _1764_ VGND VGND VPWR VPWR _1766_ sky130_fd_sc_hd__a21o_1
X_4324_ clknet_3_0__leaf_clk _0069_ net35 VGND VGND VPWR VPWR add_tmp\[31\] sky130_fd_sc_hd__dfrtp_1
X_4255_ clknet_3_3__leaf_clk net129 net35 VGND VGND VPWR VPWR net73 sky130_fd_sc_hd__dfrtp_1
X_4186_ _1290_ _1333_ VGND VGND VPWR VPWR _1334_ sky130_fd_sc_hd__or2_1
X_3206_ add_tmp\[14\] _1656_ _0319_ _0320_ VGND VGND VPWR VPWR _0052_ sky130_fd_sc_hd__a22o_1
X_3137_ _1880_ _0165_ _0250_ _1879_ VGND VGND VPWR VPWR _0252_ sky130_fd_sc_hd__a22o_1
XFILLER_0_77_421 VGND VGND VPWR VPWR sky130_fd_sc_hd__fill_2
X_3068_ _0117_ _1937_ _0118_ _0183_ VGND VGND VPWR VPWR _0184_ sky130_fd_sc_hd__nand4_1
XFILLER_0_49_178 VGND VGND VPWR VPWR sky130_fd_sc_hd__decap_6
XFILLER_0_60_365 VGND VGND VPWR VPWR sky130_fd_sc_hd__fill_2
XFILLER_0_20_207 VGND VGND VPWR VPWR sky130_fd_sc_hd__decap_6
XFILLER_0_34_29 VGND VGND VPWR VPWR sky130_fd_sc_hd__fill_2
XFILLER_0_68_410 VGND VGND VPWR VPWR sky130_fd_sc_hd__decap_8
XFILLER_0_68_421 VPWR VGND VPWR VGND sky130_ef_sc_hd__decap_12
XFILLER_0_28_307 VGND VGND VPWR VPWR sky130_fd_sc_hd__fill_1
XFILLER_0_3_429 VPWR VGND VPWR VGND sky130_ef_sc_hd__decap_12
XFILLER_0_51_343 VGND VGND VPWR VPWR sky130_fd_sc_hd__decap_3
XFILLER_0_59_48 VGND VGND VPWR VPWR sky130_fd_sc_hd__fill_1
X_2370_ net44 _1536_ _1537_ add_tmp\[17\] _1574_ VGND VGND VPWR VPWR _0019_ sky130_fd_sc_hd__a221o_1
XFILLER_0_75_69 VPWR VGND VPWR VGND sky130_ef_sc_hd__decap_12
X_4040_ _1120_ _1176_ VGND VGND VPWR VPWR _1177_ sky130_fd_sc_hd__xor2_1
XFILLER_0_59_421 VGND VGND VPWR VPWR sky130_fd_sc_hd__decap_4
XFILLER_0_24_62 VPWR VGND VPWR VGND sky130_ef_sc_hd__decap_12
XFILLER_0_24_95 VGND VGND VPWR VPWR sky130_fd_sc_hd__decap_3
X_3824_ _0856_ _0936_ _0942_ VGND VGND VPWR VPWR _0943_ sky130_fd_sc_hd__nand3_1
X_3755_ _0327_ VGND VGND VPWR VPWR _0868_ sky130_fd_sc_hd__dlymetal6s2s_1
X_3686_ _0792_ _0793_ _0789_ VGND VGND VPWR VPWR _0795_ sky130_fd_sc_hd__a21oi_1
XFILLER_0_42_365 VGND VGND VPWR VPWR sky130_fd_sc_hd__decap_4
X_2706_ _1882_ _1883_ VGND VGND VPWR VPWR _1884_ sky130_fd_sc_hd__nor2_4
X_2637_ net32 VGND VGND VPWR VPWR _1816_ sky130_fd_sc_hd__buf_6
XFILLER_0_42_376 VGND VGND VPWR VPWR sky130_fd_sc_hd__decap_4
XFILLER_0_64_3 VPWR VGND VPWR VGND sky130_ef_sc_hd__decap_12
X_2568_ _1731_ _1724_ _1728_ VGND VGND VPWR VPWR _1749_ sky130_fd_sc_hd__a21bo_1
X_2499_ _1659_ _1668_ _1673_ _1680_ VGND VGND VPWR VPWR _1683_ sky130_fd_sc_hd__and4_1
X_4307_ clknet_3_4__leaf_clk _0052_ net35 VGND VGND VPWR VPWR add_tmp\[14\] sky130_fd_sc_hd__dfrtp_1
X_4238_ _1388_ _1389_ VGND VGND VPWR VPWR _1390_ sky130_fd_sc_hd__xnor2_1
X_4169_ _1314_ _1315_ VGND VGND VPWR VPWR _1316_ sky130_fd_sc_hd__or2_1
XFILLER_0_77_240 VPWR VGND VPWR VGND sky130_ef_sc_hd__decap_12
XFILLER_0_65_435 VPWR VGND VPWR VGND sky130_ef_sc_hd__decap_12
XFILLER_0_52_107 VPWR VGND VPWR VGND sky130_ef_sc_hd__decap_12
XFILLER_0_60_184 VGND VGND VPWR VPWR sky130_fd_sc_hd__decap_8
XFILLER_0_60_195 VGND VGND VPWR VPWR sky130_fd_sc_hd__fill_1
XFILLER_0_45_17 VPWR VGND VPWR VGND sky130_ef_sc_hd__decap_12
XFILLER_0_28_159 VGND VGND VPWR VPWR sky130_fd_sc_hd__decap_4
XFILLER_0_9_39 VGND VGND VPWR VPWR sky130_fd_sc_hd__decap_8
XFILLER_0_71_449 VPWR VGND VPWR VGND sky130_ef_sc_hd__decap_12
XFILLER_0_24_354 VGND VGND VPWR VPWR sky130_fd_sc_hd__decap_3
X_3540_ _0648_ _0650_ VGND VGND VPWR VPWR _0651_ sky130_fd_sc_hd__xnor2_2
XFILLER_0_10_64 VGND VGND VPWR VPWR sky130_fd_sc_hd__decap_8
XFILLER_0_24_398 VGND VGND VPWR VPWR sky130_fd_sc_hd__fill_2
X_3471_ _0457_ _0487_ _0581_ _0582_ VGND VGND VPWR VPWR _0583_ sky130_fd_sc_hd__a211oi_2
X_2422_ _1443_ _1616_ VGND VGND VPWR VPWR _1617_ sky130_fd_sc_hd__xnor2_1
X_2353_ _1560_ add_tmp\[14\] _1522_ VGND VGND VPWR VPWR _1561_ sky130_fd_sc_hd__mux2_1
X_4023_ _1060_ _1079_ _1158_ VGND VGND VPWR VPWR _1159_ sky130_fd_sc_hd__a21oi_1
X_2284_ _1503_ VGND VGND VPWR VPWR _1504_ sky130_fd_sc_hd__clkbuf_2
XFILLER_0_59_240 VGND VGND VPWR VPWR sky130_fd_sc_hd__decap_8
XFILLER_0_19_104 VGND VGND VPWR VPWR sky130_fd_sc_hd__decap_8
XFILLER_0_59_295 VGND VGND VPWR VPWR sky130_fd_sc_hd__decap_3
XFILLER_0_74_265 VGND VGND VPWR VPWR sky130_fd_sc_hd__fill_1
X_3807_ _0755_ _0476_ VGND VGND VPWR VPWR _0924_ sky130_fd_sc_hd__nand2_1
XFILLER_0_51_82 VGND VGND VPWR VPWR sky130_fd_sc_hd__decap_6
X_3738_ _0833_ _0847_ _0848_ VGND VGND VPWR VPWR _0849_ sky130_fd_sc_hd__nand3_1
XFILLER_0_30_324 VPWR VGND VPWR VGND sky130_ef_sc_hd__decap_12
X_3669_ _0712_ _0713_ _0714_ VGND VGND VPWR VPWR _0778_ sky130_fd_sc_hd__nand3_1
XFILLER_0_42_195 VGND VGND VPWR VPWR sky130_fd_sc_hd__fill_1
XFILLER_0_53_405 VGND VGND VPWR VPWR sky130_fd_sc_hd__decap_8
XFILLER_0_53_449 VPWR VGND VPWR VGND sky130_ef_sc_hd__decap_12
XFILLER_0_65_276 VGND VGND VPWR VPWR sky130_fd_sc_hd__decap_4
XFILLER_0_33_162 VGND VGND VPWR VPWR sky130_fd_sc_hd__decap_6
XFILLER_0_21_335 VGND VGND VPWR VPWR sky130_fd_sc_hd__fill_1
XTAP_508 VGND VPWR sky130_fd_sc_hd__tapvpwrvgnd_1
XTAP_519 VGND VPWR sky130_fd_sc_hd__tapvpwrvgnd_1
XFILLER_0_56_49 VGND VGND VPWR VPWR sky130_fd_sc_hd__fill_2
XFILLER_0_72_15 VPWR VGND VPWR VGND sky130_ef_sc_hd__decap_12
X_2971_ net21 VGND VGND VPWR VPWR _0088_ sky130_fd_sc_hd__buf_2
XFILLER_0_56_265 VGND VGND VPWR VPWR sky130_fd_sc_hd__decap_8
XFILLER_0_21_85 VGND VGND VPWR VPWR sky130_fd_sc_hd__fill_1
XFILLER_0_71_279 VGND VGND VPWR VPWR sky130_fd_sc_hd__fill_1
XFILLER_0_12_313 VGND VGND VPWR VPWR sky130_fd_sc_hd__decap_6
XFILLER_0_24_173 VGND VGND VPWR VPWR sky130_fd_sc_hd__fill_1
XFILLER_0_24_195 VGND VGND VPWR VPWR sky130_fd_sc_hd__fill_1
X_3523_ _1962_ _0633_ _0630_ _0631_ VGND VGND VPWR VPWR _0634_ sky130_fd_sc_hd__a22o_1
X_3454_ _0464_ _0461_ _0463_ VGND VGND VPWR VPWR _0566_ sky130_fd_sc_hd__a21bo_1
X_2405_ _1433_ _1437_ VGND VGND VPWR VPWR _1603_ sky130_fd_sc_hd__nand2_1
X_3385_ _0490_ _0497_ VGND VGND VPWR VPWR _0498_ sky130_fd_sc_hd__xnor2_1
X_2336_ _1016_ _1319_ _1340_ VGND VGND VPWR VPWR _1547_ sky130_fd_sc_hd__a21oi_1
X_2267_ _1489_ VGND VGND VPWR VPWR _1490_ sky130_fd_sc_hd__buf_2
XFILLER_0_27_3 VGND VGND VPWR VPWR sky130_fd_sc_hd__decap_8
X_4006_ _0249_ _0371_ _0859_ VGND VGND VPWR VPWR _1140_ sky130_fd_sc_hd__and3_1
X_2198_ _1420_ _1421_ VGND VGND VPWR VPWR _1422_ sky130_fd_sc_hd__and2b_1
XFILLER_0_47_210 VGND VGND VPWR VPWR sky130_fd_sc_hd__fill_2
XFILLER_0_35_405 VGND VGND VPWR VPWR sky130_fd_sc_hd__fill_1
XFILLER_0_7_373 VPWR VGND VPWR VGND sky130_ef_sc_hd__decap_12
XFILLER_0_35_449 VGND VGND VPWR VPWR sky130_fd_sc_hd__decap_8
XFILLER_0_15_151 VPWR VGND VPWR VGND sky130_ef_sc_hd__decap_12
XFILLER_0_50_419 VGND VGND VPWR VPWR sky130_fd_sc_hd__fill_1
XFILLER_0_30_110 VPWR VGND VPWR VGND sky130_ef_sc_hd__decap_12
XFILLER_0_30_176 VGND VGND VPWR VPWR sky130_fd_sc_hd__decap_6
XFILLER_0_42_29 VGND VGND VPWR VPWR sky130_fd_sc_hd__decap_6
XFILLER_0_53_202 VGND VGND VPWR VPWR sky130_fd_sc_hd__fill_2
XFILLER_0_61_290 VGND VGND VPWR VPWR sky130_fd_sc_hd__decap_8
XFILLER_0_6_29 VGND VGND VPWR VPWR sky130_fd_sc_hd__decap_8
XTAP_305 VGND VPWR sky130_fd_sc_hd__tapvpwrvgnd_1
XFILLER_0_67_15 VPWR VGND VPWR VGND sky130_ef_sc_hd__decap_12
XTAP_316 VGND VPWR sky130_fd_sc_hd__tapvpwrvgnd_1
XTAP_327 VGND VPWR sky130_fd_sc_hd__tapvpwrvgnd_1
XTAP_338 VGND VPWR sky130_fd_sc_hd__tapvpwrvgnd_1
XTAP_349 VGND VPWR sky130_fd_sc_hd__tapvpwrvgnd_1
X_3170_ _0283_ _0275_ _0276_ VGND VGND VPWR VPWR _0285_ sky130_fd_sc_hd__nand3_2
Xrebuffer18 _0300_ VGND VGND VPWR VPWR net91 sky130_fd_sc_hd__clkbuf_1
Xrebuffer29 _0137_ VGND VGND VPWR VPWR net102 sky130_fd_sc_hd__clkbuf_1
XFILLER_0_8_126 VGND VGND VPWR VPWR sky130_fd_sc_hd__fill_1
XFILLER_0_29_265 VPWR VGND VPWR VGND sky130_ef_sc_hd__decap_12
X_2954_ _0071_ VGND VGND VPWR VPWR _0049_ sky130_fd_sc_hd__clkbuf_1
XFILLER_0_17_449 VGND VGND VPWR VPWR sky130_fd_sc_hd__decap_4
X_2885_ _1752_ net34 net20 net10 VGND VGND VPWR VPWR _2060_ sky130_fd_sc_hd__a22o_1
XFILLER_0_4_321 VGND VGND VPWR VPWR sky130_fd_sc_hd__decap_3
XFILLER_0_44_279 VPWR VGND VPWR VGND sky130_ef_sc_hd__decap_12
XFILLER_0_4_365 VGND VGND VPWR VPWR sky130_fd_sc_hd__decap_3
X_3506_ _1880_ _1996_ _0077_ net23 VGND VGND VPWR VPWR _0617_ sky130_fd_sc_hd__and4_1
XFILLER_0_12_176 VGND VGND VPWR VPWR sky130_fd_sc_hd__decap_6
X_3437_ _0449_ _0277_ _0547_ _0548_ VGND VGND VPWR VPWR _0549_ sky130_fd_sc_hd__nand4_2
X_3368_ _0459_ _0479_ _0480_ VGND VGND VPWR VPWR _0481_ sky130_fd_sc_hd__and3_1
X_2319_ _1286_ _1532_ VGND VGND VPWR VPWR _1533_ sky130_fd_sc_hd__nand2_1
XFILLER_0_57_81 VPWR VGND VPWR VGND sky130_ef_sc_hd__decap_12
X_3299_ _0324_ _0411_ _0412_ VGND VGND VPWR VPWR _0413_ sky130_fd_sc_hd__nand3_2
XFILLER_0_67_349 VPWR VGND VPWR VGND sky130_ef_sc_hd__decap_12
XFILLER_0_35_246 VGND VGND VPWR VPWR sky130_fd_sc_hd__decap_3
XFILLER_0_16_460 VGND VGND VPWR VPWR sky130_fd_sc_hd__decap_3
XFILLER_0_50_227 VPWR VGND VPWR VGND sky130_ef_sc_hd__decap_12
XFILLER_0_43_290 VGND VGND VPWR VPWR sky130_fd_sc_hd__decap_8
Xoutput43 net43 VGND VGND VPWR VPWR out_acc[16] sky130_fd_sc_hd__clkbuf_4
Xoutput54 net54 VGND VGND VPWR VPWR out_acc[26] sky130_fd_sc_hd__clkbuf_4
Xoutput65 net65 VGND VGND VPWR VPWR out_acc[3] sky130_fd_sc_hd__clkbuf_4
XFILLER_0_66_360 VGND VGND VPWR VPWR sky130_fd_sc_hd__decap_4
XFILLER_0_14_419 VGND VGND VPWR VPWR sky130_fd_sc_hd__fill_1
X_2670_ _1789_ _1781_ _1780_ VGND VGND VPWR VPWR _1849_ sky130_fd_sc_hd__a21bo_1
XFILLER_0_1_302 VGND VGND VPWR VPWR sky130_fd_sc_hd__decap_8
X_4271_ clknet_3_5__leaf_clk _0016_ net35 VGND VGND VPWR VPWR net41 sky130_fd_sc_hd__dfrtp_2
XTAP_157 VGND VPWR sky130_fd_sc_hd__tapvpwrvgnd_1
X_3222_ _1673_ _0335_ _0330_ _0333_ VGND VGND VPWR VPWR _0336_ sky130_fd_sc_hd__nand4_2
XTAP_168 VGND VPWR sky130_fd_sc_hd__tapvpwrvgnd_1
XTAP_179 VGND VPWR sky130_fd_sc_hd__tapvpwrvgnd_1
X_3153_ net8 VGND VGND VPWR VPWR _0268_ sky130_fd_sc_hd__buf_2
XFILLER_0_27_95 VPWR VGND VPWR VGND sky130_ef_sc_hd__decap_12
X_3084_ net100 _0126_ _0125_ VGND VGND VPWR VPWR _0200_ sky130_fd_sc_hd__a21bo_1
XFILLER_0_49_305 VGND VGND VPWR VPWR sky130_fd_sc_hd__decap_6
XFILLER_0_49_349 VPWR VGND VPWR VGND sky130_ef_sc_hd__decap_12
X_3986_ _1113_ _1117_ _1655_ VGND VGND VPWR VPWR _1119_ sky130_fd_sc_hd__a21o_1
X_2937_ net110 _2110_ _2027_ net74 VGND VGND VPWR VPWR _2112_ sky130_fd_sc_hd__o211ai_2
XFILLER_0_57_393 VGND VGND VPWR VPWR sky130_fd_sc_hd__decap_8
XFILLER_0_72_363 VGND VGND VPWR VPWR sky130_fd_sc_hd__fill_1
X_2868_ _2031_ _2032_ _2043_ VGND VGND VPWR VPWR _2044_ sky130_fd_sc_hd__a21oi_1
X_2799_ _1663_ _1975_ VGND VGND VPWR VPWR _1976_ sky130_fd_sc_hd__nand2_1
XFILLER_0_4_195 VGND VGND VPWR VPWR sky130_fd_sc_hd__fill_1
XFILLER_0_40_260 VGND VGND VPWR VPWR sky130_fd_sc_hd__decap_8
XTAP_680 VGND VPWR sky130_fd_sc_hd__tapvpwrvgnd_1
XTAP_691 VGND VPWR sky130_fd_sc_hd__tapvpwrvgnd_1
XFILLER_0_55_308 VPWR VGND VPWR VGND sky130_ef_sc_hd__decap_12
XFILLER_0_67_146 VGND VGND VPWR VPWR sky130_fd_sc_hd__decap_6
Xrebuffer9 _2111_ VGND VGND VPWR VPWR net82 sky130_fd_sc_hd__clkbuf_2
XFILLER_0_48_17 VGND VGND VPWR VPWR sky130_fd_sc_hd__decap_8
XFILLER_0_48_39 VGND VGND VPWR VPWR sky130_fd_sc_hd__decap_4
XFILLER_0_58_113 VGND VGND VPWR VPWR sky130_fd_sc_hd__fill_2
XFILLER_0_58_124 VGND VGND VPWR VPWR sky130_fd_sc_hd__decap_8
X_3840_ _0833_ _0847_ _0848_ VGND VGND VPWR VPWR _0960_ sky130_fd_sc_hd__and3_1
X_3771_ _0882_ _0883_ net80 _0832_ VGND VGND VPWR VPWR _0885_ sky130_fd_sc_hd__o211a_1
XFILLER_0_39_393 VPWR VGND VPWR VGND sky130_ef_sc_hd__decap_12
XFILLER_0_13_97 VGND VGND VPWR VPWR sky130_fd_sc_hd__fill_2
XFILLER_0_13_86 VGND VGND VPWR VPWR sky130_fd_sc_hd__fill_1
X_2722_ net31 VGND VGND VPWR VPWR _1900_ sky130_fd_sc_hd__clkbuf_2
X_2653_ _1826_ _1828_ _1831_ VGND VGND VPWR VPWR _1832_ sky130_fd_sc_hd__nand3_1
X_2584_ _1762_ _1763_ _1764_ VGND VGND VPWR VPWR _1765_ sky130_fd_sc_hd__and3_1
X_4323_ clknet_3_0__leaf_clk _0068_ net35 VGND VGND VPWR VPWR add_tmp\[30\] sky130_fd_sc_hd__dfrtp_1
XFILLER_0_1_154 VPWR VGND VPWR VGND sky130_ef_sc_hd__decap_12
XFILLER_0_66_7 VPWR VGND VPWR VGND sky130_ef_sc_hd__decap_12
X_4254_ clknet_3_2__leaf_clk _0001_ net35 VGND VGND VPWR VPWR clr_delay sky130_fd_sc_hd__dfrtp_1
X_4185_ _0746_ _1195_ _1289_ VGND VGND VPWR VPWR _1333_ sky130_fd_sc_hd__a21oi_1
X_3205_ net146 _0318_ _1490_ VGND VGND VPWR VPWR _0320_ sky130_fd_sc_hd__o21a_1
X_3136_ _1879_ _1880_ _0250_ VGND VGND VPWR VPWR _0251_ sky130_fd_sc_hd__and3_1
X_3067_ net7 VGND VGND VPWR VPWR _0183_ sky130_fd_sc_hd__clkbuf_2
XFILLER_0_49_113 VGND VGND VPWR VPWR sky130_fd_sc_hd__fill_1
XFILLER_0_49_124 VGND VGND VPWR VPWR sky130_fd_sc_hd__decap_4
XFILLER_0_49_146 VGND VGND VPWR VPWR sky130_fd_sc_hd__fill_2
XFILLER_0_37_308 VGND VGND VPWR VPWR sky130_fd_sc_hd__decap_3
XFILLER_0_64_105 VGND VGND VPWR VPWR sky130_fd_sc_hd__decap_8
XFILLER_0_64_149 VGND VGND VPWR VPWR sky130_fd_sc_hd__decap_4
X_3969_ _1024_ _1028_ _1099_ VGND VGND VPWR VPWR _1100_ sky130_fd_sc_hd__or3_1
XFILLER_0_60_377 VGND VGND VPWR VPWR sky130_fd_sc_hd__decap_4
XFILLER_0_68_433 VPWR VGND VPWR VGND sky130_ef_sc_hd__decap_12
XFILLER_0_50_29 VGND VGND VPWR VPWR sky130_fd_sc_hd__decap_4
XFILLER_0_70_108 VGND VGND VPWR VPWR sky130_fd_sc_hd__decap_6
XFILLER_0_36_374 VGND VGND VPWR VPWR sky130_fd_sc_hd__fill_1
XFILLER_0_63_193 VGND VGND VPWR VPWR sky130_fd_sc_hd__decap_3
XFILLER_0_51_377 VGND VGND VPWR VPWR sky130_fd_sc_hd__decap_6
XFILLER_0_75_15 VPWR VGND VPWR VGND sky130_ef_sc_hd__decap_12
XFILLER_0_24_41 VGND VGND VPWR VPWR sky130_fd_sc_hd__decap_8
XFILLER_0_24_74 VGND VGND VPWR VPWR sky130_fd_sc_hd__fill_2
XFILLER_0_24_85 VGND VGND VPWR VPWR sky130_fd_sc_hd__decap_3
X_3823_ _0937_ _0938_ _0939_ _0941_ VGND VGND VPWR VPWR _0942_ sky130_fd_sc_hd__or4_4
XFILLER_0_27_363 VGND VGND VPWR VPWR sky130_fd_sc_hd__fill_2
XFILLER_0_61_108 VGND VGND VPWR VPWR sky130_fd_sc_hd__decap_4
XFILLER_0_6_257 VGND VGND VPWR VPWR sky130_fd_sc_hd__decap_6
X_3754_ _0857_ VGND VGND VPWR VPWR _0867_ sky130_fd_sc_hd__dlymetal6s2s_1
X_3685_ _0789_ _0792_ _0793_ VGND VGND VPWR VPWR _0794_ sky130_fd_sc_hd__and3_1
XFILLER_0_42_344 VGND VGND VPWR VPWR sky130_fd_sc_hd__decap_4
X_2705_ _1706_ _1840_ _1783_ _1825_ VGND VGND VPWR VPWR _1883_ sky130_fd_sc_hd__and4_1
X_2636_ _1784_ _1788_ _1785_ VGND VGND VPWR VPWR _1815_ sky130_fd_sc_hd__o21ba_1
X_2567_ _1746_ _1743_ _1745_ VGND VGND VPWR VPWR _1748_ sky130_fd_sc_hd__nand3_1
XFILLER_0_49_82 VGND VGND VPWR VPWR sky130_fd_sc_hd__fill_1
X_2498_ _1669_ _1673_ _1681_ _1659_ VGND VGND VPWR VPWR _1682_ sky130_fd_sc_hd__a22oi_2
X_4306_ clknet_3_5__leaf_clk _0051_ net35 VGND VGND VPWR VPWR add_tmp\[13\] sky130_fd_sc_hd__dfrtp_1
X_4237_ _1320_ _1328_ _1359_ _1360_ VGND VGND VPWR VPWR _1389_ sky130_fd_sc_hd__a31oi_2
X_4168_ _1280_ _1281_ _1313_ VGND VGND VPWR VPWR _1315_ sky130_fd_sc_hd__o21a_1
XFILLER_0_65_70 VPWR VGND VPWR VGND sky130_ef_sc_hd__decap_12
X_4099_ _0867_ _0476_ VGND VGND VPWR VPWR _1240_ sky130_fd_sc_hd__nand2_1
X_3119_ _0234_ VGND VGND VPWR VPWR _0051_ sky130_fd_sc_hd__clkbuf_1
XFILLER_0_69_219 VGND VGND VPWR VPWR sky130_fd_sc_hd__decap_4
XFILLER_0_77_296 VPWR VGND VPWR VGND sky130_ef_sc_hd__decap_12
XFILLER_0_65_447 VGND VGND VPWR VPWR sky130_fd_sc_hd__fill_1
XFILLER_0_52_119 VGND VGND VPWR VPWR sky130_fd_sc_hd__decap_3
XFILLER_0_33_355 VGND VGND VPWR VPWR sky130_fd_sc_hd__fill_2
XFILLER_0_60_141 VGND VGND VPWR VPWR sky130_fd_sc_hd__decap_6
XFILLER_0_45_29 VGND VGND VPWR VPWR sky130_fd_sc_hd__decap_4
XFILLER_0_71_417 VGND VGND VPWR VPWR sky130_fd_sc_hd__fill_2
XFILLER_0_10_43 VGND VGND VPWR VPWR sky130_fd_sc_hd__decap_8
X_3470_ _0580_ _0557_ _0558_ VGND VGND VPWR VPWR _0582_ sky130_fd_sc_hd__and3_1
XFILLER_0_10_98 VGND VGND VPWR VPWR sky130_fd_sc_hd__fill_2
X_2421_ _1444_ _1611_ VGND VGND VPWR VPWR _1616_ sky130_fd_sc_hd__nand2_1
X_2352_ _0940_ _1559_ VGND VGND VPWR VPWR _1560_ sky130_fd_sc_hd__xnor2_1
XFILLER_0_19_74 VPWR VGND VPWR VGND sky130_ef_sc_hd__decap_12
X_2283_ _1487_ en_delay VGND VGND VPWR VPWR _1503_ sky130_fd_sc_hd__and2_1
X_4022_ _1061_ _1078_ VGND VGND VPWR VPWR _1158_ sky130_fd_sc_hd__and2_1
XFILLER_0_29_7 VGND VGND VPWR VPWR sky130_fd_sc_hd__fill_2
XFILLER_0_35_40 VPWR VGND VPWR VGND sky130_ef_sc_hd__decap_12
XFILLER_0_47_447 VGND VGND VPWR VPWR sky130_fd_sc_hd__fill_1
XFILLER_0_59_285 VGND VGND VPWR VPWR sky130_fd_sc_hd__decap_4
XFILLER_0_74_211 VGND VGND VPWR VPWR sky130_fd_sc_hd__decap_3
XFILLER_0_47_458 VGND VGND VPWR VPWR sky130_fd_sc_hd__decap_4
X_3806_ _0921_ _0922_ VGND VGND VPWR VPWR _0923_ sky130_fd_sc_hd__nor2_1
XFILLER_0_15_333 VGND VGND VPWR VPWR sky130_fd_sc_hd__decap_3
X_3737_ _0846_ _0839_ _0840_ VGND VGND VPWR VPWR _0848_ sky130_fd_sc_hd__nand3_2
XFILLER_0_42_130 VGND VGND VPWR VPWR sky130_fd_sc_hd__decap_8
XFILLER_0_30_303 VGND VGND VPWR VPWR sky130_fd_sc_hd__fill_1
XFILLER_0_42_141 VGND VGND VPWR VPWR sky130_fd_sc_hd__decap_6
XFILLER_0_42_152 VGND VGND VPWR VPWR sky130_fd_sc_hd__decap_8
X_3668_ _0775_ _0776_ VGND VGND VPWR VPWR _0777_ sky130_fd_sc_hd__nor2_1
XFILLER_0_30_336 VPWR VGND VPWR VGND sky130_ef_sc_hd__decap_12
X_2619_ _1798_ VGND VGND VPWR VPWR _1799_ sky130_fd_sc_hd__clkbuf_2
X_3599_ _2010_ _0192_ _0331_ VGND VGND VPWR VPWR _0709_ sky130_fd_sc_hd__o21a_2
XFILLER_0_25_108 VGND VGND VPWR VPWR sky130_fd_sc_hd__decap_4
XFILLER_0_61_461 VGND VGND VPWR VPWR sky130_fd_sc_hd__fill_2
XFILLER_0_33_174 VGND VGND VPWR VPWR sky130_fd_sc_hd__fill_2
XTAP_509 VGND VPWR sky130_fd_sc_hd__tapvpwrvgnd_1
XFILLER_0_72_27 VGND VGND VPWR VPWR sky130_fd_sc_hd__fill_1
X_2970_ _1701_ _0082_ _0084_ _0086_ VGND VGND VPWR VPWR _0087_ sky130_fd_sc_hd__o2bb2a_1
XFILLER_0_16_119 VGND VGND VPWR VPWR sky130_fd_sc_hd__decap_3
XFILLER_0_71_203 VGND VGND VPWR VPWR sky130_fd_sc_hd__fill_2
XFILLER_0_71_225 VPWR VGND VPWR VGND sky130_ef_sc_hd__decap_12
X_3522_ _2092_ VGND VGND VPWR VPWR _0633_ sky130_fd_sc_hd__buf_2
X_3453_ _2085_ _0088_ _0562_ _0563_ VGND VGND VPWR VPWR _0565_ sky130_fd_sc_hd__nand4_2
X_2404_ net51 _1580_ _1581_ add_tmp\[23\] _1602_ VGND VGND VPWR VPWR _0025_ sky130_fd_sc_hd__a221o_1
X_3384_ _0495_ _0496_ VGND VGND VPWR VPWR _0497_ sky130_fd_sc_hd__nor2_1
X_2335_ _0994_ _1330_ VGND VGND VPWR VPWR _1546_ sky130_fd_sc_hd__or2_1
X_2266_ net2 VGND VGND VPWR VPWR _1489_ sky130_fd_sc_hd__dlymetal6s2s_1
X_4005_ _1068_ _1071_ _1069_ VGND VGND VPWR VPWR _1139_ sky130_fd_sc_hd__a21bo_1
X_2197_ net49 add_tmp\[21\] VGND VGND VPWR VPWR _1421_ sky130_fd_sc_hd__nand2_1
XFILLER_0_1_96 VPWR VGND VPWR VGND sky130_ef_sc_hd__decap_12
XFILLER_0_35_439 VGND VGND VPWR VPWR sky130_fd_sc_hd__decap_8
XFILLER_0_15_163 VGND VGND VPWR VPWR sky130_fd_sc_hd__decap_4
XFILLER_0_7_385 VGND VGND VPWR VPWR sky130_fd_sc_hd__decap_6
XFILLER_0_43_461 VGND VGND VPWR VPWR sky130_fd_sc_hd__fill_2
XFILLER_0_30_122 VGND VGND VPWR VPWR sky130_fd_sc_hd__decap_6
XFILLER_0_11_380 VPWR VGND VPWR VGND sky130_ef_sc_hd__decap_12
Xhold65 add_tmp\[10\] VGND VGND VPWR VPWR net138 sky130_fd_sc_hd__dlygate4sd3_1
XFILLER_0_53_225 VGND VGND VPWR VPWR sky130_fd_sc_hd__decap_3
XFILLER_0_21_111 VGND VGND VPWR VPWR sky130_fd_sc_hd__fill_1
XTAP_306 VGND VPWR sky130_fd_sc_hd__tapvpwrvgnd_1
XFILLER_0_67_27 VGND VGND VPWR VPWR sky130_fd_sc_hd__decap_6
XTAP_317 VGND VPWR sky130_fd_sc_hd__tapvpwrvgnd_1
XTAP_328 VGND VPWR sky130_fd_sc_hd__tapvpwrvgnd_1
XTAP_339 VGND VPWR sky130_fd_sc_hd__tapvpwrvgnd_1
Xrebuffer19 _0303_ VGND VGND VPWR VPWR net92 sky130_fd_sc_hd__clkbuf_1
X_2953_ add_tmp\[11\] _0070_ _1991_ VGND VGND VPWR VPWR _0071_ sky130_fd_sc_hd__mux2_1
XFILLER_0_69_391 VGND VGND VPWR VPWR sky130_fd_sc_hd__fill_1
XFILLER_0_29_277 VGND VGND VPWR VPWR sky130_fd_sc_hd__decap_3
XFILLER_0_32_63 VPWR VGND VPWR VGND sky130_ef_sc_hd__decap_12
XFILLER_0_44_214 VGND VGND VPWR VPWR sky130_fd_sc_hd__fill_2
X_2884_ net10 _1729_ net34 net20 VGND VGND VPWR VPWR _2059_ sky130_fd_sc_hd__and4_1
X_3505_ _1929_ _0077_ _0470_ _2006_ VGND VGND VPWR VPWR _0616_ sky130_fd_sc_hd__a22oi_1
XFILLER_0_52_291 VPWR VGND VPWR VGND sky130_ef_sc_hd__decap_12
X_3436_ _1959_ _1817_ _2093_ _0278_ VGND VGND VPWR VPWR _0548_ sky130_fd_sc_hd__nand4_2
X_3367_ _0478_ _0468_ _0469_ VGND VGND VPWR VPWR _0480_ sky130_fd_sc_hd__nand3_1
X_2318_ net70 add_tmp\[8\] VGND VGND VPWR VPWR _1532_ sky130_fd_sc_hd__or2_1
XFILLER_0_57_93 VPWR VGND VPWR VGND sky130_ef_sc_hd__decap_12
X_3298_ _0409_ _0410_ _0307_ _0309_ VGND VGND VPWR VPWR _0412_ sky130_fd_sc_hd__o211ai_2
X_2249_ _1465_ _1471_ _1472_ _1459_ VGND VGND VPWR VPWR _1473_ sky130_fd_sc_hd__o211a_1
XFILLER_0_73_81 VGND VGND VPWR VPWR sky130_fd_sc_hd__decap_8
XFILLER_0_35_225 VGND VGND VPWR VPWR sky130_fd_sc_hd__fill_1
XFILLER_0_35_269 VGND VGND VPWR VPWR sky130_fd_sc_hd__decap_8
XFILLER_0_50_239 VPWR VGND VPWR VGND sky130_ef_sc_hd__decap_12
Xoutput44 net44 VGND VGND VPWR VPWR out_acc[17] sky130_fd_sc_hd__clkbuf_4
Xoutput55 net55 VGND VGND VPWR VPWR out_acc[27] sky130_fd_sc_hd__clkbuf_4
XFILLER_0_9_3 VPWR VGND VPWR VGND sky130_ef_sc_hd__decap_12
Xoutput66 net66 VGND VGND VPWR VPWR out_acc[4] sky130_fd_sc_hd__clkbuf_4
XFILLER_0_58_306 VGND VGND VPWR VPWR sky130_fd_sc_hd__fill_2
XPHY_150 VGND VGND VPWR VPWR sky130_fd_sc_hd__decap_3
XFILLER_0_34_280 VPWR VGND VPWR VGND sky130_ef_sc_hd__decap_12
X_4270_ clknet_3_7__leaf_clk _0015_ net35 VGND VGND VPWR VPWR net40 sky130_fd_sc_hd__dfrtp_4
X_3221_ _0326_ VGND VGND VPWR VPWR _0335_ sky130_fd_sc_hd__buf_2
XTAP_158 VGND VPWR sky130_fd_sc_hd__tapvpwrvgnd_1
XTAP_169 VGND VPWR sky130_fd_sc_hd__tapvpwrvgnd_1
X_3152_ net7 VGND VGND VPWR VPWR _0267_ sky130_fd_sc_hd__buf_2
XFILLER_0_27_30 VGND VGND VPWR VPWR sky130_fd_sc_hd__fill_2
X_3083_ _0197_ _0189_ _0190_ VGND VGND VPWR VPWR _0199_ sky130_fd_sc_hd__nand3_1
XFILLER_0_43_73 VGND VGND VPWR VPWR sky130_fd_sc_hd__fill_1
X_3985_ _1113_ _1117_ VGND VGND VPWR VPWR _1118_ sky130_fd_sc_hd__nor2_1
XFILLER_0_57_372 VGND VGND VPWR VPWR sky130_fd_sc_hd__decap_8
XFILLER_0_64_309 VGND VGND VPWR VPWR sky130_fd_sc_hd__fill_2
X_2936_ _2027_ _2072_ _2108_ _2110_ VGND VGND VPWR VPWR _2111_ sky130_fd_sc_hd__a211o_1
X_2867_ _2041_ _2042_ VGND VGND VPWR VPWR _2043_ sky130_fd_sc_hd__and2_4
XFILLER_0_72_353 VGND VGND VPWR VPWR sky130_fd_sc_hd__fill_2
XFILLER_0_4_141 VPWR VGND VPWR VGND sky130_ef_sc_hd__decap_12
XFILLER_0_32_228 VGND VGND VPWR VPWR sky130_fd_sc_hd__fill_1
X_2798_ _1974_ VGND VGND VPWR VPWR _1975_ sky130_fd_sc_hd__dlymetal6s2s_1
XFILLER_0_0_391 VGND VGND VPWR VPWR sky130_fd_sc_hd__fill_1
X_3419_ _1687_ _0530_ _0422_ _0423_ VGND VGND VPWR VPWR _0531_ sky130_fd_sc_hd__a22oi_2
XTAP_670 VGND VPWR sky130_fd_sc_hd__tapvpwrvgnd_1
XTAP_681 VGND VPWR sky130_fd_sc_hd__tapvpwrvgnd_1
XTAP_692 VGND VPWR sky130_fd_sc_hd__tapvpwrvgnd_1
XFILLER_0_67_169 VPWR VGND VPWR VGND sky130_ef_sc_hd__decap_12
XFILLER_0_63_386 VGND VGND VPWR VPWR sky130_fd_sc_hd__decap_6
XFILLER_0_48_29 VGND VGND VPWR VPWR sky130_fd_sc_hd__decap_6
XFILLER_0_46_309 VGND VGND VPWR VPWR sky130_fd_sc_hd__decap_4
X_3770_ net80 _0832_ _0882_ _0883_ VGND VGND VPWR VPWR _0884_ sky130_fd_sc_hd__a211oi_4
XFILLER_0_13_65 VGND VGND VPWR VPWR sky130_fd_sc_hd__decap_3
XFILLER_0_54_331 VGND VGND VPWR VPWR sky130_fd_sc_hd__decap_4
XFILLER_0_66_180 VGND VGND VPWR VPWR sky130_fd_sc_hd__fill_1
X_2721_ _1896_ _1897_ _1898_ _1666_ VGND VGND VPWR VPWR _1899_ sky130_fd_sc_hd__a22oi_1
XFILLER_0_54_342 VPWR VGND VPWR VGND sky130_ef_sc_hd__decap_12
X_2652_ _1695_ _1693_ _1829_ _1830_ VGND VGND VPWR VPWR _1831_ sky130_fd_sc_hd__nand4_2
X_2583_ _1719_ _1735_ _1734_ VGND VGND VPWR VPWR _1764_ sky130_fd_sc_hd__a21o_1
X_4322_ clknet_3_0__leaf_clk _0067_ net35 VGND VGND VPWR VPWR add_tmp\[29\] sky130_fd_sc_hd__dfrtp_1
XFILLER_0_1_166 VGND VGND VPWR VPWR sky130_fd_sc_hd__fill_2
X_4253_ _1392_ _1403_ _1405_ _0321_ _0831_ VGND VGND VPWR VPWR _0069_ sky130_fd_sc_hd__a32o_1
X_3204_ net146 _0318_ VGND VGND VPWR VPWR _0319_ sky130_fd_sc_hd__nand2_1
X_4184_ _1283_ _1292_ _1236_ VGND VGND VPWR VPWR _1332_ sky130_fd_sc_hd__o21a_1
XFILLER_0_38_73 VGND VGND VPWR VPWR sky130_fd_sc_hd__decap_3
X_3135_ net20 VGND VGND VPWR VPWR _0250_ sky130_fd_sc_hd__buf_1
X_3066_ _1866_ _0120_ _0181_ _1936_ VGND VGND VPWR VPWR _0182_ sky130_fd_sc_hd__a22o_1
XFILLER_0_77_401 VPWR VGND VPWR VGND sky130_ef_sc_hd__decap_12
XFILLER_0_9_255 VPWR VGND VPWR VGND sky130_ef_sc_hd__decap_12
X_3968_ _1096_ _1098_ VGND VGND VPWR VPWR _1099_ sky130_fd_sc_hd__nor2_1
X_2919_ net5 VGND VGND VPWR VPWR _2094_ sky130_fd_sc_hd__clkbuf_2
X_3899_ _1008_ _1022_ _1023_ VGND VGND VPWR VPWR _1024_ sky130_fd_sc_hd__and3_1
XFILLER_0_60_312 VGND VGND VPWR VPWR sky130_fd_sc_hd__decap_6
XFILLER_0_5_461 VGND VGND VPWR VPWR sky130_fd_sc_hd__fill_2
XFILLER_0_72_194 VGND VGND VPWR VPWR sky130_fd_sc_hd__fill_2
XFILLER_0_13_250 VGND VGND VPWR VPWR sky130_fd_sc_hd__fill_2
XFILLER_0_68_445 VPWR VGND VPWR VGND sky130_ef_sc_hd__decap_12
XFILLER_0_55_117 VGND VGND VPWR VPWR sky130_fd_sc_hd__decap_4
XFILLER_0_51_323 VGND VGND VPWR VPWR sky130_fd_sc_hd__decap_6
XFILLER_0_51_334 VGND VGND VPWR VPWR sky130_fd_sc_hd__fill_2
XFILLER_0_75_27 VPWR VGND VPWR VGND sky130_ef_sc_hd__decap_12
XFILLER_0_59_456 VGND VGND VPWR VPWR sky130_fd_sc_hd__fill_1
X_3822_ _0100_ _1821_ _0859_ VGND VGND VPWR VPWR _0941_ sky130_fd_sc_hd__o21ai_1
XFILLER_0_46_139 VGND VGND VPWR VPWR sky130_fd_sc_hd__fill_1
XFILLER_0_6_225 VGND VGND VPWR VPWR sky130_fd_sc_hd__decap_4
XFILLER_0_27_353 VGND VGND VPWR VPWR sky130_fd_sc_hd__decap_4
X_3753_ _0862_ _0863_ _0856_ VGND VGND VPWR VPWR _0866_ sky130_fd_sc_hd__a21o_1
XFILLER_0_40_41 VGND VGND VPWR VPWR sky130_fd_sc_hd__decap_6
XFILLER_0_40_52 VGND VGND VPWR VPWR sky130_fd_sc_hd__decap_8
XFILLER_0_6_269 VGND VGND VPWR VPWR sky130_fd_sc_hd__decap_8
X_3684_ _0647_ _0790_ _0791_ VGND VGND VPWR VPWR _0793_ sky130_fd_sc_hd__nand3_1
XFILLER_0_40_85 VPWR VGND VPWR VGND sky130_ef_sc_hd__decap_12
X_2704_ _1879_ _1841_ _1880_ _1881_ VGND VGND VPWR VPWR _1882_ sky130_fd_sc_hd__a22oi_4
X_2635_ _1691_ _1812_ _1813_ _1814_ VGND VGND VPWR VPWR _0044_ sky130_fd_sc_hd__a31o_1
XFILLER_0_10_253 VPWR VGND VPWR VGND sky130_ef_sc_hd__decap_12
X_2566_ _1743_ _1745_ _1746_ VGND VGND VPWR VPWR _1747_ sky130_fd_sc_hd__a21o_1
X_4305_ clknet_3_6__leaf_clk _0050_ net35 VGND VGND VPWR VPWR add_tmp\[12\] sky130_fd_sc_hd__dfrtp_1
X_2497_ _1680_ VGND VGND VPWR VPWR _1681_ sky130_fd_sc_hd__buf_2
X_4236_ _1385_ _1387_ VGND VGND VPWR VPWR _1388_ sky130_fd_sc_hd__xnor2_1
XFILLER_0_4_41 VGND VGND VPWR VPWR sky130_fd_sc_hd__decap_4
X_4167_ _1280_ _1281_ _1313_ VGND VGND VPWR VPWR _1314_ sky130_fd_sc_hd__nor3_1
XFILLER_0_4_85 VPWR VGND VPWR VGND sky130_ef_sc_hd__decap_12
X_3118_ add_tmp\[13\] _0233_ _1991_ VGND VGND VPWR VPWR _0234_ sky130_fd_sc_hd__mux2_1
XFILLER_0_65_82 VGND VGND VPWR VPWR sky130_fd_sc_hd__fill_2
X_4098_ _1237_ _1238_ VGND VGND VPWR VPWR _1239_ sky130_fd_sc_hd__nand2_1
X_3049_ net34 VGND VGND VPWR VPWR _0165_ sky130_fd_sc_hd__clkbuf_2
XFILLER_0_77_253 VGND VGND VPWR VPWR sky130_fd_sc_hd__decap_8
XFILLER_0_45_194 VGND VGND VPWR VPWR sky130_fd_sc_hd__decap_8
XFILLER_0_60_197 VGND VGND VPWR VPWR sky130_fd_sc_hd__decap_4
XFILLER_0_56_415 VGND VGND VPWR VPWR sky130_fd_sc_hd__decap_4
XFILLER_0_61_29 VGND VGND VPWR VPWR sky130_fd_sc_hd__fill_2
XFILLER_0_3_206 VGND VGND VPWR VPWR sky130_fd_sc_hd__decap_4
X_2420_ _1615_ VGND VGND VPWR VPWR _0028_ sky130_fd_sc_hd__clkbuf_1
X_2351_ _0951_ _1372_ VGND VGND VPWR VPWR _1559_ sky130_fd_sc_hd__nor2_1
X_2282_ _1501_ VGND VGND VPWR VPWR _1502_ sky130_fd_sc_hd__clkbuf_2
X_4021_ _1153_ _1155_ VGND VGND VPWR VPWR _1156_ sky130_fd_sc_hd__xnor2_1
XFILLER_0_19_86 VGND VGND VPWR VPWR sky130_fd_sc_hd__decap_8
XFILLER_0_35_52 VGND VGND VPWR VPWR sky130_fd_sc_hd__decap_4
XFILLER_0_35_63 VGND VGND VPWR VPWR sky130_fd_sc_hd__fill_1
XFILLER_0_19_139 VPWR VGND VPWR VGND sky130_ef_sc_hd__decap_12
XFILLER_0_47_437 VGND VGND VPWR VPWR sky130_fd_sc_hd__fill_1
XFILLER_0_51_40 VGND VGND VPWR VPWR sky130_fd_sc_hd__fill_1
XFILLER_0_62_407 VPWR VGND VPWR VGND sky130_ef_sc_hd__decap_12
X_3805_ _0757_ _0629_ _0569_ _0471_ VGND VGND VPWR VPWR _0922_ sky130_fd_sc_hd__and4_1
X_3736_ _0839_ _0840_ _0846_ VGND VGND VPWR VPWR _0847_ sky130_fd_sc_hd__a21o_1
XFILLER_0_27_183 VGND VGND VPWR VPWR sky130_fd_sc_hd__fill_2
XFILLER_0_42_120 VGND VGND VPWR VPWR sky130_fd_sc_hd__decap_6
X_3667_ _0774_ _0772_ _0773_ VGND VGND VPWR VPWR _0776_ sky130_fd_sc_hd__and3_1
XFILLER_0_2_283 VGND VGND VPWR VPWR sky130_fd_sc_hd__fill_1
XFILLER_0_30_348 VGND VGND VPWR VPWR sky130_fd_sc_hd__decap_8
X_2618_ _1797_ VGND VGND VPWR VPWR _1798_ sky130_fd_sc_hd__clkbuf_2
X_3598_ _2010_ _1755_ net9 VGND VGND VPWR VPWR _0708_ sky130_fd_sc_hd__nand3_2
X_2549_ _1729_ _1730_ VGND VGND VPWR VPWR _1731_ sky130_fd_sc_hd__and2_1
X_4219_ _1368_ _0744_ _1288_ _1290_ VGND VGND VPWR VPWR _1369_ sky130_fd_sc_hd__a211oi_2
XFILLER_0_65_223 VGND VGND VPWR VPWR sky130_fd_sc_hd__fill_1
XFILLER_0_53_418 VGND VGND VPWR VPWR sky130_fd_sc_hd__fill_2
XFILLER_0_18_172 VGND VGND VPWR VPWR sky130_fd_sc_hd__fill_2
XFILLER_0_21_337 VGND VGND VPWR VPWR sky130_fd_sc_hd__fill_1
XFILLER_0_21_348 VPWR VGND VPWR VGND sky130_ef_sc_hd__decap_12
XFILLER_0_56_29 VPWR VGND VPWR VGND sky130_ef_sc_hd__decap_12
XFILLER_0_56_278 VPWR VGND VPWR VGND sky130_ef_sc_hd__decap_12
XFILLER_0_21_54 VGND VGND VPWR VPWR sky130_fd_sc_hd__fill_2
XFILLER_0_71_237 VGND VGND VPWR VPWR sky130_fd_sc_hd__decap_6
X_3521_ _0449_ _0629_ _0630_ _0631_ VGND VGND VPWR VPWR _0632_ sky130_fd_sc_hd__nand4_1
X_3452_ _0561_ _0164_ _0562_ _0563_ VGND VGND VPWR VPWR _0564_ sky130_fd_sc_hd__a22o_1
X_2403_ _1499_ _1601_ VGND VGND VPWR VPWR _1602_ sky130_fd_sc_hd__nor2_1
X_3383_ _0491_ _0392_ _0494_ VGND VGND VPWR VPWR _0496_ sky130_fd_sc_hd__and3_1
X_2334_ _1545_ VGND VGND VPWR VPWR _0012_ sky130_fd_sc_hd__clkbuf_1
X_2265_ _1487_ VGND VGND VPWR VPWR _1488_ sky130_fd_sc_hd__clkbuf_2
X_4004_ _1136_ _1137_ VGND VGND VPWR VPWR _1138_ sky130_fd_sc_hd__xnor2_1
X_2196_ net49 add_tmp\[21\] VGND VGND VPWR VPWR _1420_ sky130_fd_sc_hd__nor2_1
XFILLER_0_35_418 VPWR VGND VPWR VGND sky130_ef_sc_hd__decap_12
X_3719_ _0743_ _0745_ _0749_ VGND VGND VPWR VPWR _0828_ sky130_fd_sc_hd__or3_1
XFILLER_0_70_281 VPWR VGND VPWR VGND sky130_ef_sc_hd__decap_12
XFILLER_0_15_197 VPWR VGND VPWR VGND sky130_ef_sc_hd__decap_12
XFILLER_0_30_134 VGND VGND VPWR VPWR sky130_fd_sc_hd__decap_6
Xhold66 add_tmp\[9\] VGND VGND VPWR VPWR net139 sky130_fd_sc_hd__dlygate4sd3_1
XFILLER_0_21_167 VGND VGND VPWR VPWR sky130_fd_sc_hd__fill_1
XTAP_307 VGND VPWR sky130_fd_sc_hd__tapvpwrvgnd_1
XTAP_318 VGND VPWR sky130_fd_sc_hd__tapvpwrvgnd_1
XTAP_329 VGND VPWR sky130_fd_sc_hd__tapvpwrvgnd_1
XFILLER_0_76_318 VGND VGND VPWR VPWR sky130_fd_sc_hd__decap_6
X_2952_ _2124_ _2126_ VGND VGND VPWR VPWR _0070_ sky130_fd_sc_hd__xnor2_1
XFILLER_0_17_407 VGND VGND VPWR VPWR sky130_fd_sc_hd__decap_8
XFILLER_0_44_204 VGND VGND VPWR VPWR sky130_fd_sc_hd__decap_3
XFILLER_0_32_75 VGND VGND VPWR VPWR sky130_fd_sc_hd__fill_1
X_2883_ _1998_ net113 _2057_ VGND VGND VPWR VPWR _2058_ sky130_fd_sc_hd__o21ai_2
XFILLER_0_25_462 VGND VGND VPWR VPWR sky130_fd_sc_hd__fill_1
XFILLER_0_12_101 VGND VGND VPWR VPWR sky130_fd_sc_hd__fill_1
X_3504_ _0612_ _0613_ _0563_ _0565_ VGND VGND VPWR VPWR _0615_ sky130_fd_sc_hd__o211ai_2
X_3435_ _0445_ _2093_ _0278_ _1798_ VGND VGND VPWR VPWR _0547_ sky130_fd_sc_hd__a22o_1
X_3366_ _0468_ _0469_ _0478_ VGND VGND VPWR VPWR _0479_ sky130_fd_sc_hd__a21o_1
X_2317_ net69 _1502_ _1504_ net131 _1531_ VGND VGND VPWR VPWR _0009_ sky130_fd_sc_hd__a221o_1
X_3297_ _0307_ _0309_ _0409_ _0410_ VGND VGND VPWR VPWR _0411_ sky130_fd_sc_hd__a211o_4
X_2248_ _1462_ _1460_ VGND VGND VPWR VPWR _1472_ sky130_fd_sc_hd__or2b_1
XFILLER_0_32_3 VGND VGND VPWR VPWR sky130_fd_sc_hd__decap_8
X_2179_ net42 add_tmp\[15\] VGND VGND VPWR VPWR _1383_ sky130_fd_sc_hd__nand2_1
Xoutput67 net67 VGND VGND VPWR VPWR out_acc[5] sky130_fd_sc_hd__clkbuf_4
Xoutput45 net45 VGND VGND VPWR VPWR out_acc[18] sky130_fd_sc_hd__clkbuf_4
Xoutput56 net56 VGND VGND VPWR VPWR out_acc[28] sky130_fd_sc_hd__clkbuf_4
XPHY_151 VGND VGND VPWR VPWR sky130_fd_sc_hd__decap_3
XPHY_140 VGND VGND VPWR VPWR sky130_fd_sc_hd__decap_3
XFILLER_0_22_421 VGND VGND VPWR VPWR sky130_fd_sc_hd__decap_6
XFILLER_0_34_292 VGND VGND VPWR VPWR sky130_fd_sc_hd__decap_8
XFILLER_0_1_337 VGND VGND VPWR VPWR sky130_fd_sc_hd__decap_4
X_3220_ _1672_ _0327_ _0330_ _0333_ VGND VGND VPWR VPWR _0334_ sky130_fd_sc_hd__a22o_2
XTAP_159 VGND VPWR sky130_fd_sc_hd__tapvpwrvgnd_1
X_3151_ _1866_ _0181_ _0265_ _1936_ VGND VGND VPWR VPWR _0266_ sky130_fd_sc_hd__a22o_1
XFILLER_0_27_42 VPWR VGND VPWR VGND sky130_ef_sc_hd__decap_12
XFILLER_0_27_75 VGND VGND VPWR VPWR sky130_fd_sc_hd__decap_8
X_3082_ _0189_ _0190_ _0197_ VGND VGND VPWR VPWR _0198_ sky130_fd_sc_hd__a21o_1
XFILLER_0_43_30 VGND VGND VPWR VPWR sky130_fd_sc_hd__decap_8
XFILLER_0_9_404 VPWR VGND VPWR VGND sky130_ef_sc_hd__decap_12
XFILLER_0_43_85 VGND VGND VPWR VPWR sky130_fd_sc_hd__fill_1
X_3984_ _0823_ _0982_ _1115_ _1116_ VGND VGND VPWR VPWR _1117_ sky130_fd_sc_hd__o31a_4
X_2935_ _2109_ net120 net118 VGND VGND VPWR VPWR _2110_ sky130_fd_sc_hd__a21oi_2
XFILLER_0_72_321 VPWR VGND VPWR VGND sky130_ef_sc_hd__decap_12
XFILLER_0_17_259 VPWR VGND VPWR VGND sky130_ef_sc_hd__decap_12
X_2866_ _2033_ _2034_ _2040_ VGND VGND VPWR VPWR _2042_ sky130_fd_sc_hd__or3_1
XFILLER_0_13_410 VPWR VGND VPWR VGND sky130_ef_sc_hd__decap_12
XFILLER_0_4_153 VPWR VGND VPWR VGND sky130_ef_sc_hd__decap_12
XFILLER_0_25_281 VPWR VGND VPWR VGND sky130_ef_sc_hd__decap_12
X_2797_ _1973_ VGND VGND VPWR VPWR _1974_ sky130_fd_sc_hd__clkbuf_2
XFILLER_0_4_197 VPWR VGND VPWR VGND sky130_ef_sc_hd__decap_12
XFILLER_0_40_251 VGND VGND VPWR VPWR sky130_fd_sc_hd__fill_1
X_3418_ _0332_ VGND VGND VPWR VPWR _0530_ sky130_fd_sc_hd__clkbuf_2
X_3349_ _0250_ VGND VGND VPWR VPWR _0462_ sky130_fd_sc_hd__buf_2
XTAP_660 VGND VPWR sky130_fd_sc_hd__tapvpwrvgnd_1
XTAP_671 VGND VPWR sky130_fd_sc_hd__tapvpwrvgnd_1
XTAP_682 VGND VPWR sky130_fd_sc_hd__tapvpwrvgnd_1
XTAP_693 VGND VPWR sky130_fd_sc_hd__tapvpwrvgnd_1
XFILLER_0_48_384 VGND VGND VPWR VPWR sky130_fd_sc_hd__fill_2
XFILLER_0_64_29 VGND VGND VPWR VPWR sky130_fd_sc_hd__fill_2
XFILLER_0_58_137 VGND VGND VPWR VPWR sky130_fd_sc_hd__decap_3
XFILLER_0_13_55 VGND VGND VPWR VPWR sky130_fd_sc_hd__fill_1
XFILLER_0_54_321 VGND VGND VPWR VPWR sky130_fd_sc_hd__decap_6
X_2720_ _1816_ VGND VGND VPWR VPWR _1898_ sky130_fd_sc_hd__buf_6
XFILLER_0_54_354 VGND VGND VPWR VPWR sky130_fd_sc_hd__decap_8
X_2651_ net16 VGND VGND VPWR VPWR _1830_ sky130_fd_sc_hd__clkbuf_2
XFILLER_0_54_365 VPWR VGND VPWR VGND sky130_ef_sc_hd__decap_12
XFILLER_0_54_398 VGND VGND VPWR VPWR sky130_fd_sc_hd__fill_2
XFILLER_0_10_402 VGND VGND VPWR VPWR sky130_fd_sc_hd__decap_3
XFILLER_0_22_251 VGND VGND VPWR VPWR sky130_fd_sc_hd__fill_1
X_2582_ _1761_ _1750_ _1751_ VGND VGND VPWR VPWR _1763_ sky130_fd_sc_hd__nand3_1
X_4321_ clknet_3_1__leaf_clk _0066_ net35 VGND VGND VPWR VPWR add_tmp\[28\] sky130_fd_sc_hd__dfrtp_1
X_4252_ _1385_ _1387_ _1401_ _1402_ _1054_ VGND VGND VPWR VPWR _1405_ sky130_fd_sc_hd__o221a_1
XFILLER_0_38_52 VGND VGND VPWR VPWR sky130_fd_sc_hd__fill_2
X_3203_ _0316_ _0317_ VGND VGND VPWR VPWR _0318_ sky130_fd_sc_hd__or2b_1
X_4183_ _1316_ _1317_ VGND VGND VPWR VPWR _1331_ sky130_fd_sc_hd__and2b_1
XFILLER_0_38_85 VGND VGND VPWR VPWR sky130_fd_sc_hd__decap_4
X_3134_ _0165_ VGND VGND VPWR VPWR _0249_ sky130_fd_sc_hd__clkbuf_2
X_3065_ net7 VGND VGND VPWR VPWR _0181_ sky130_fd_sc_hd__clkbuf_2
XFILLER_0_77_413 VGND VGND VPWR VPWR sky130_fd_sc_hd__decap_6
X_3967_ _0761_ _0746_ _1019_ _1097_ _1018_ VGND VGND VPWR VPWR _1098_ sky130_fd_sc_hd__a311oi_1
XFILLER_0_9_267 VGND VGND VPWR VPWR sky130_fd_sc_hd__fill_1
X_2918_ _2092_ VGND VGND VPWR VPWR _2093_ sky130_fd_sc_hd__buf_6
X_3898_ _1021_ _1014_ _1015_ VGND VGND VPWR VPWR _1023_ sky130_fd_sc_hd__nand3_1
XFILLER_0_45_365 VGND VGND VPWR VPWR sky130_fd_sc_hd__fill_1
XFILLER_0_72_162 VPWR VGND VPWR VGND sky130_ef_sc_hd__decap_12
X_2849_ _2022_ _2023_ _2014_ VGND VGND VPWR VPWR _2025_ sky130_fd_sc_hd__a21o_1
XFILLER_0_60_346 VGND VGND VPWR VPWR sky130_fd_sc_hd__decap_8
XTAP_490 VGND VPWR sky130_fd_sc_hd__tapvpwrvgnd_1
XFILLER_0_68_457 VGND VGND VPWR VPWR sky130_fd_sc_hd__decap_6
XFILLER_0_36_365 VGND VGND VPWR VPWR sky130_fd_sc_hd__fill_1
XFILLER_0_63_184 VGND VGND VPWR VPWR sky130_fd_sc_hd__decap_3
XFILLER_0_51_368 VGND VGND VPWR VPWR sky130_fd_sc_hd__fill_2
XFILLER_0_75_39 VPWR VGND VPWR VGND sky130_ef_sc_hd__decap_12
XFILLER_0_59_402 VPWR VGND VPWR VGND sky130_ef_sc_hd__decap_12
XFILLER_0_24_21 VGND VGND VPWR VPWR sky130_fd_sc_hd__decap_6
XFILLER_0_59_435 VGND VGND VPWR VPWR sky130_fd_sc_hd__decap_3
XFILLER_0_74_416 VGND VGND VPWR VPWR sky130_fd_sc_hd__decap_4
XFILLER_0_27_310 VPWR VGND VPWR VGND sky130_ef_sc_hd__decap_12
X_3821_ _1798_ _0445_ _0328_ VGND VGND VPWR VPWR _0939_ sky130_fd_sc_hd__and3_1
XFILLER_0_46_118 VGND VGND VPWR VPWR sky130_fd_sc_hd__fill_1
XFILLER_0_27_343 VGND VGND VPWR VPWR sky130_fd_sc_hd__fill_2
X_3752_ _0856_ _0862_ _0863_ VGND VGND VPWR VPWR _0865_ sky130_fd_sc_hd__nand3_1
XFILLER_0_54_151 VGND VGND VPWR VPWR sky130_fd_sc_hd__decap_3
X_3683_ _0790_ _0791_ _0647_ VGND VGND VPWR VPWR _0792_ sky130_fd_sc_hd__a21o_1
X_2703_ _1753_ VGND VGND VPWR VPWR _1881_ sky130_fd_sc_hd__buf_2
XFILLER_0_2_410 VGND VGND VPWR VPWR sky130_fd_sc_hd__decap_8
XFILLER_0_2_421 VPWR VGND VPWR VGND sky130_ef_sc_hd__decap_12
X_2634_ add_tmp\[6\] _1655_ VGND VGND VPWR VPWR _1814_ sky130_fd_sc_hd__and2_1
X_2565_ _1730_ _1721_ VGND VGND VPWR VPWR _1746_ sky130_fd_sc_hd__and2_1
XFILLER_0_10_243 VGND VGND VPWR VPWR sky130_fd_sc_hd__fill_2
X_4304_ clknet_3_7__leaf_clk _0049_ net35 VGND VGND VPWR VPWR add_tmp\[11\] sky130_fd_sc_hd__dfrtp_1
XFILLER_0_10_265 VPWR VGND VPWR VGND sky130_ef_sc_hd__decap_12
X_2496_ _1679_ VGND VGND VPWR VPWR _1680_ sky130_fd_sc_hd__clkbuf_2
X_4235_ _1352_ _1354_ _1386_ VGND VGND VPWR VPWR _1387_ sky130_fd_sc_hd__a21oi_1
X_4166_ _1305_ _1312_ VGND VGND VPWR VPWR _1313_ sky130_fd_sc_hd__xnor2_1
XFILLER_0_4_97 VPWR VGND VPWR VGND sky130_ef_sc_hd__decap_12
X_3117_ _0150_ _0232_ VGND VGND VPWR VPWR _0233_ sky130_fd_sc_hd__xor2_1
X_4097_ _0157_ _1133_ _0868_ _1141_ VGND VGND VPWR VPWR _1238_ sky130_fd_sc_hd__nand4_1
X_3048_ _2061_ VGND VGND VPWR VPWR _0164_ sky130_fd_sc_hd__buf_2
XFILLER_0_65_449 VPWR VGND VPWR VGND sky130_ef_sc_hd__decap_12
XFILLER_0_18_321 VGND VGND VPWR VPWR sky130_fd_sc_hd__decap_4
XFILLER_0_33_335 VGND VGND VPWR VPWR sky130_fd_sc_hd__fill_1
XFILLER_0_5_270 VGND VGND VPWR VPWR sky130_fd_sc_hd__decap_4
XFILLER_0_68_210 VPWR VGND VPWR VGND sky130_ef_sc_hd__decap_12
XFILLER_0_24_313 VGND VGND VPWR VPWR sky130_fd_sc_hd__fill_1
XFILLER_0_24_346 VGND VGND VPWR VPWR sky130_fd_sc_hd__decap_8
XFILLER_0_36_195 VGND VGND VPWR VPWR sky130_fd_sc_hd__fill_1
XFILLER_0_3_229 VPWR VGND VPWR VGND sky130_ef_sc_hd__decap_12
X_2350_ net40 _1536_ _1537_ add_tmp\[13\] _1558_ VGND VGND VPWR VPWR _0015_ sky130_fd_sc_hd__a221o_1
X_2281_ _1484_ VGND VGND VPWR VPWR _1501_ sky130_fd_sc_hd__clkbuf_2
X_4020_ _1089_ _1080_ _1082_ _1154_ VGND VGND VPWR VPWR _1155_ sky130_fd_sc_hd__a31o_1
XFILLER_0_47_405 VPWR VGND VPWR VGND sky130_ef_sc_hd__decap_12
XFILLER_0_74_246 VGND VGND VPWR VPWR sky130_fd_sc_hd__fill_1
X_3804_ _0837_ _0156_ _0159_ _0757_ VGND VGND VPWR VPWR _0921_ sky130_fd_sc_hd__a22oi_1
XFILLER_0_27_151 VGND VGND VPWR VPWR sky130_fd_sc_hd__decap_6
XFILLER_0_51_74 VGND VGND VPWR VPWR sky130_fd_sc_hd__decap_4
XFILLER_0_62_419 VGND VGND VPWR VPWR sky130_fd_sc_hd__fill_1
X_3735_ _0844_ _0845_ VGND VGND VPWR VPWR _0846_ sky130_fd_sc_hd__xnor2_1
XFILLER_0_15_357 VGND VGND VPWR VPWR sky130_fd_sc_hd__fill_2
X_3666_ _0772_ _0773_ _0774_ VGND VGND VPWR VPWR _0775_ sky130_fd_sc_hd__a21oi_1
XFILLER_0_2_251 VGND VGND VPWR VPWR sky130_fd_sc_hd__fill_1
X_2617_ net31 VGND VGND VPWR VPWR _1797_ sky130_fd_sc_hd__buf_6
X_3597_ _0705_ _0703_ _0704_ VGND VGND VPWR VPWR _0707_ sky130_fd_sc_hd__and3_1
XFILLER_0_62_3 VPWR VGND VPWR VGND sky130_ef_sc_hd__decap_12
X_2548_ net27 VGND VGND VPWR VPWR _1730_ sky130_fd_sc_hd__buf_6
X_4218_ _1195_ VGND VGND VPWR VPWR _1368_ sky130_fd_sc_hd__inv_2
X_2479_ _1659_ _1664_ _1490_ VGND VGND VPWR VPWR _1665_ sky130_fd_sc_hd__and3_1
X_4149_ _1285_ _1293_ VGND VGND VPWR VPWR _1294_ sky130_fd_sc_hd__and2_1
XFILLER_0_61_430 VGND VGND VPWR VPWR sky130_fd_sc_hd__fill_2
XFILLER_0_33_154 VGND VGND VPWR VPWR sky130_fd_sc_hd__fill_1
XFILLER_0_21_327 VGND VGND VPWR VPWR sky130_fd_sc_hd__decap_8
XFILLER_0_72_29 VPWR VGND VPWR VGND sky130_ef_sc_hd__decap_12
XFILLER_0_29_405 VPWR VGND VPWR VGND sky130_ef_sc_hd__decap_12
XFILLER_0_29_449 VPWR VGND VPWR VGND sky130_ef_sc_hd__decap_12
X_3520_ _1959_ _0445_ _0278_ _0118_ VGND VGND VPWR VPWR _0631_ sky130_fd_sc_hd__nand4_2
XFILLER_0_24_165 VGND VGND VPWR VPWR sky130_fd_sc_hd__decap_8
X_3451_ _1938_ _1868_ _1973_ _0083_ VGND VGND VPWR VPWR _0563_ sky130_fd_sc_hd__nand4_4
X_3382_ _0491_ _0392_ _0494_ VGND VGND VPWR VPWR _0495_ sky130_fd_sc_hd__a21oi_1
X_2402_ _1599_ _1600_ VGND VGND VPWR VPWR _1601_ sky130_fd_sc_hd__xor2_1
X_2333_ net37 _1544_ _1495_ VGND VGND VPWR VPWR _1545_ sky130_fd_sc_hd__mux2_1
X_2264_ clr_delay VGND VGND VPWR VPWR _1487_ sky130_fd_sc_hd__dlymetal6s2s_1
X_4003_ _0912_ _0398_ VGND VGND VPWR VPWR _1137_ sky130_fd_sc_hd__nand2_1
XFILLER_0_46_74 VGND VGND VPWR VPWR sky130_fd_sc_hd__fill_2
X_2195_ _1417_ _1411_ _1418_ _1408_ VGND VGND VPWR VPWR _1419_ sky130_fd_sc_hd__o211a_1
X_3718_ _0807_ _0805_ VGND VGND VPWR VPWR _0827_ sky130_fd_sc_hd__or2b_1
X_3649_ _0633_ _2036_ _0430_ _0460_ VGND VGND VPWR VPWR _0758_ sky130_fd_sc_hd__a22o_1
XFILLER_0_70_293 VPWR VGND VPWR VGND sky130_ef_sc_hd__decap_12
Xhold56 en_delay VGND VGND VPWR VPWR net129 sky130_fd_sc_hd__dlygate4sd3_1
Xhold67 add_tmp\[8\] VGND VGND VPWR VPWR net140 sky130_fd_sc_hd__dlygate4sd3_1
XFILLER_0_26_419 VGND VGND VPWR VPWR sky130_fd_sc_hd__fill_1
XFILLER_0_53_216 VGND VGND VPWR VPWR sky130_fd_sc_hd__decap_3
XFILLER_0_53_249 VGND VGND VPWR VPWR sky130_fd_sc_hd__decap_4
XFILLER_0_21_113 VGND VGND VPWR VPWR sky130_fd_sc_hd__decap_6
XFILLER_0_21_124 VPWR VGND VPWR VGND sky130_ef_sc_hd__decap_12
XFILLER_0_21_179 VGND VGND VPWR VPWR sky130_fd_sc_hd__decap_3
XTAP_308 VGND VPWR sky130_fd_sc_hd__tapvpwrvgnd_1
XTAP_319 VGND VPWR sky130_fd_sc_hd__tapvpwrvgnd_1
XFILLER_0_69_371 VPWR VGND VPWR VGND sky130_ef_sc_hd__decap_12
XFILLER_0_8_118 VGND VGND VPWR VPWR sky130_fd_sc_hd__fill_1
X_2951_ _2049_ _2125_ _2053_ VGND VGND VPWR VPWR _2126_ sky130_fd_sc_hd__a21oi_1
X_2882_ _1995_ _2004_ VGND VGND VPWR VPWR _2057_ sky130_fd_sc_hd__or2b_1
XFILLER_0_40_411 VGND VGND VPWR VPWR sky130_fd_sc_hd__decap_4
X_3503_ _0563_ _0565_ _0612_ _0613_ VGND VGND VPWR VPWR _0614_ sky130_fd_sc_hd__a211o_1
X_3434_ _2008_ _0340_ _0435_ _0434_ _0433_ VGND VGND VPWR VPWR _0546_ sky130_fd_sc_hd__a32o_1
X_3365_ _0475_ _0477_ VGND VGND VPWR VPWR _0478_ sky130_fd_sc_hd__xnor2_1
X_2316_ _1265_ _1049_ _1254_ _1530_ VGND VGND VPWR VPWR _1531_ sky130_fd_sc_hd__o31a_1
X_3296_ _0408_ _0396_ _0397_ VGND VGND VPWR VPWR _0410_ sky130_fd_sc_hd__and3_4
X_2247_ _1467_ _1457_ _1456_ VGND VGND VPWR VPWR _1471_ sky130_fd_sc_hd__a21o_1
XFILLER_0_25_3 VPWR VGND VPWR VGND sky130_ef_sc_hd__decap_12
X_2178_ _0984_ _0994_ _1351_ _1362_ _0962_ VGND VGND VPWR VPWR _1372_ sky130_fd_sc_hd__o311a_1
XFILLER_0_67_319 VGND VGND VPWR VPWR sky130_fd_sc_hd__fill_2
XFILLER_0_35_216 VGND VGND VPWR VPWR sky130_fd_sc_hd__decap_8
XFILLER_0_7_162 VGND VGND VPWR VPWR sky130_fd_sc_hd__decap_6
XFILLER_0_43_271 VGND VGND VPWR VPWR sky130_fd_sc_hd__decap_8
Xoutput46 net46 VGND VGND VPWR VPWR out_acc[19] sky130_fd_sc_hd__clkbuf_4
Xoutput57 net57 VGND VGND VPWR VPWR out_acc[29] sky130_fd_sc_hd__clkbuf_4
Xoutput68 net68 VGND VGND VPWR VPWR out_acc[6] sky130_fd_sc_hd__clkbuf_4
XPHY_152 VGND VGND VPWR VPWR sky130_fd_sc_hd__decap_3
XPHY_130 VGND VGND VPWR VPWR sky130_fd_sc_hd__decap_3
XPHY_141 VGND VGND VPWR VPWR sky130_fd_sc_hd__decap_3
Xclkbuf_3_1__f_clk clknet_0_clk VGND VGND VPWR VPWR clknet_3_1__leaf_clk sky130_fd_sc_hd__clkbuf_16
XFILLER_0_41_208 VPWR VGND VPWR VGND sky130_ef_sc_hd__decap_12
X_3150_ net8 VGND VGND VPWR VPWR _0265_ sky130_fd_sc_hd__clkbuf_2
XFILLER_0_27_54 VGND VGND VPWR VPWR sky130_fd_sc_hd__fill_2
X_3081_ _0195_ _0196_ VGND VGND VPWR VPWR _0197_ sky130_fd_sc_hd__nor2_1
XFILLER_0_49_319 VGND VGND VPWR VPWR sky130_fd_sc_hd__decap_4
XFILLER_0_9_416 VPWR VGND VPWR VGND sky130_ef_sc_hd__decap_12
XFILLER_0_43_53 VGND VGND VPWR VPWR sky130_fd_sc_hd__decap_3
XFILLER_0_9_449 VPWR VGND VPWR VGND sky130_ef_sc_hd__decap_12
XFILLER_0_43_97 VGND VGND VPWR VPWR sky130_fd_sc_hd__decap_3
X_3983_ _1051_ _1047_ _1115_ _0985_ _1048_ VGND VGND VPWR VPWR _1116_ sky130_fd_sc_hd__o221a_1
XFILLER_0_17_205 VGND VGND VPWR VPWR sky130_fd_sc_hd__decap_3
X_2934_ _2106_ VGND VGND VPWR VPWR _2109_ sky130_fd_sc_hd__clkbuf_2
X_2865_ _2033_ _2034_ _2040_ VGND VGND VPWR VPWR _2041_ sky130_fd_sc_hd__o21ai_1
XFILLER_0_72_333 VPWR VGND VPWR VGND sky130_ef_sc_hd__decap_12
XFILLER_0_72_388 VGND VGND VPWR VPWR sky130_fd_sc_hd__fill_1
XFILLER_0_13_422 VGND VGND VPWR VPWR sky130_fd_sc_hd__decap_3
XFILLER_0_4_165 VPWR VGND VPWR VGND sky130_ef_sc_hd__decap_12
XFILLER_0_25_293 VGND VGND VPWR VPWR sky130_fd_sc_hd__decap_6
X_2796_ net34 VGND VGND VPWR VPWR _1973_ sky130_fd_sc_hd__buf_2
XFILLER_0_68_50 VGND VGND VPWR VPWR sky130_fd_sc_hd__decap_4
X_3417_ _1723_ _1726_ _1730_ net9 VGND VGND VPWR VPWR _0529_ sky130_fd_sc_hd__nand4_4
XFILLER_0_68_83 VGND VGND VPWR VPWR sky130_fd_sc_hd__fill_1
XFILLER_0_0_393 VPWR VGND VPWR VGND sky130_ef_sc_hd__decap_12
X_3348_ _0108_ _0460_ _0371_ _2085_ VGND VGND VPWR VPWR _0461_ sky130_fd_sc_hd__a22o_1
XTAP_650 VGND VPWR sky130_fd_sc_hd__tapvpwrvgnd_1
XTAP_661 VGND VPWR sky130_fd_sc_hd__tapvpwrvgnd_1
XTAP_672 VGND VPWR sky130_fd_sc_hd__tapvpwrvgnd_1
XTAP_683 VGND VPWR sky130_fd_sc_hd__tapvpwrvgnd_1
XTAP_694 VGND VPWR sky130_fd_sc_hd__tapvpwrvgnd_1
X_3279_ _0391_ _0392_ VGND VGND VPWR VPWR _0393_ sky130_fd_sc_hd__nand2_1
XFILLER_0_63_300 VGND VGND VPWR VPWR sky130_fd_sc_hd__fill_1
XFILLER_0_58_105 VGND VGND VPWR VPWR sky130_fd_sc_hd__decap_8
XFILLER_0_39_385 VGND VGND VPWR VPWR sky130_fd_sc_hd__decap_6
X_2650_ net15 VGND VGND VPWR VPWR _1829_ sky130_fd_sc_hd__clkbuf_2
XFILLER_0_54_377 VGND VGND VPWR VPWR sky130_fd_sc_hd__fill_1
XFILLER_0_1_113 VGND VGND VPWR VPWR sky130_fd_sc_hd__decap_6
X_2581_ _1750_ _1751_ _1761_ VGND VGND VPWR VPWR _1762_ sky130_fd_sc_hd__a21o_1
XFILLER_0_1_146 VGND VGND VPWR VPWR sky130_fd_sc_hd__fill_1
X_4320_ clknet_3_1__leaf_clk _0065_ net35 VGND VGND VPWR VPWR add_tmp\[27\] sky130_fd_sc_hd__dfrtp_1
X_4251_ _1401_ _1402_ VGND VGND VPWR VPWR _1403_ sky130_fd_sc_hd__nand2_1
XFILLER_0_38_20 VGND VGND VPWR VPWR sky130_fd_sc_hd__fill_1
X_3202_ _2122_ _0072_ _0073_ _0147_ _0232_ VGND VGND VPWR VPWR _0317_ sky130_fd_sc_hd__a311o_1
X_4182_ net134 _0321_ _1328_ _1329_ VGND VGND VPWR VPWR _0066_ sky130_fd_sc_hd__a22o_1
X_3133_ _1955_ _2063_ VGND VGND VPWR VPWR _0248_ sky130_fd_sc_hd__nand2_2
XFILLER_0_54_41 VPWR VGND VPWR VGND sky130_ef_sc_hd__decap_12
X_3064_ _0106_ _0130_ net128 VGND VGND VPWR VPWR _0180_ sky130_fd_sc_hd__nand3_1
XFILLER_0_77_447 VGND VGND VPWR VPWR sky130_fd_sc_hd__fill_1
XFILLER_0_49_138 VGND VGND VPWR VPWR sky130_fd_sc_hd__decap_8
XFILLER_0_54_85 VGND VGND VPWR VPWR sky130_fd_sc_hd__decap_8
X_3966_ _0761_ _0747_ VGND VGND VPWR VPWR _1097_ sky130_fd_sc_hd__nor2_1
XFILLER_0_57_160 VGND VGND VPWR VPWR sky130_fd_sc_hd__fill_1
XFILLER_0_70_51 VPWR VGND VPWR VGND sky130_ef_sc_hd__decap_12
XFILLER_0_9_279 VGND VGND VPWR VPWR sky130_fd_sc_hd__fill_1
XFILLER_0_45_333 VGND VGND VPWR VPWR sky130_fd_sc_hd__decap_3
XFILLER_0_45_355 VGND VGND VPWR VPWR sky130_fd_sc_hd__fill_1
X_2917_ net4 VGND VGND VPWR VPWR _2092_ sky130_fd_sc_hd__buf_6
XFILLER_0_57_193 VPWR VGND VPWR VGND sky130_ef_sc_hd__decap_12
X_3897_ _1014_ _1015_ _1021_ VGND VGND VPWR VPWR _1022_ sky130_fd_sc_hd__a21o_1
XFILLER_0_5_430 VPWR VGND VPWR VGND sky130_ef_sc_hd__decap_12
XFILLER_0_72_141 VGND VGND VPWR VPWR sky130_fd_sc_hd__decap_8
XFILLER_0_72_174 VPWR VGND VPWR VGND sky130_ef_sc_hd__decap_12
X_2848_ _2014_ _2022_ _2023_ VGND VGND VPWR VPWR _2024_ sky130_fd_sc_hd__nand3_2
XFILLER_0_60_325 VGND VGND VPWR VPWR sky130_fd_sc_hd__fill_1
X_2779_ _1787_ VGND VGND VPWR VPWR _1956_ sky130_fd_sc_hd__clkbuf_2
XFILLER_0_60_358 VGND VGND VPWR VPWR sky130_fd_sc_hd__fill_2
XFILLER_0_0_9 VGND VGND VPWR VPWR sky130_fd_sc_hd__fill_1
XTAP_480 VGND VPWR sky130_fd_sc_hd__tapvpwrvgnd_1
XTAP_491 VGND VPWR sky130_fd_sc_hd__tapvpwrvgnd_1
XFILLER_0_48_171 VGND VGND VPWR VPWR sky130_fd_sc_hd__decap_4
XFILLER_0_51_314 VGND VGND VPWR VPWR sky130_fd_sc_hd__fill_2
XFILLER_0_59_447 VGND VGND VPWR VPWR sky130_fd_sc_hd__fill_1
X_3820_ _0268_ VGND VGND VPWR VPWR _0938_ sky130_fd_sc_hd__inv_2
X_3751_ _0205_ _0858_ _0860_ _0861_ VGND VGND VPWR VPWR _0863_ sky130_fd_sc_hd__a22o_1
XFILLER_0_27_322 VGND VGND VPWR VPWR sky130_fd_sc_hd__decap_4
X_2702_ net14 VGND VGND VPWR VPWR _1880_ sky130_fd_sc_hd__clkbuf_2
XFILLER_0_54_163 VGND VGND VPWR VPWR sky130_fd_sc_hd__decap_4
X_3682_ _1956_ _0779_ _0709_ VGND VGND VPWR VPWR _0791_ sky130_fd_sc_hd__nand3_1
XFILLER_0_42_325 VGND VGND VPWR VPWR sky130_fd_sc_hd__decap_4
X_2633_ _1811_ _1808_ _1810_ VGND VGND VPWR VPWR _1813_ sky130_fd_sc_hd__or3_4
XFILLER_0_2_433 VPWR VGND VPWR VGND sky130_ef_sc_hd__decap_12
X_2564_ _1725_ _1726_ _1727_ _1744_ VGND VGND VPWR VPWR _1745_ sky130_fd_sc_hd__nand4_2
X_4303_ clknet_3_6__leaf_clk _0048_ net35 VGND VGND VPWR VPWR add_tmp\[10\] sky130_fd_sc_hd__dfrtp_1
XFILLER_0_50_391 VGND VGND VPWR VPWR sky130_fd_sc_hd__decap_8
XFILLER_0_10_277 VPWR VGND VPWR VGND sky130_ef_sc_hd__decap_12
X_2495_ _1678_ VGND VGND VPWR VPWR _1679_ sky130_fd_sc_hd__clkbuf_2
X_4234_ _1355_ _1357_ VGND VGND VPWR VPWR _1386_ sky130_fd_sc_hd__and2b_1
X_4165_ _1258_ _1311_ VGND VGND VPWR VPWR _1312_ sky130_fd_sc_hd__xnor2_1
X_3116_ net79 _0231_ VGND VGND VPWR VPWR _0232_ sky130_fd_sc_hd__xnor2_1
X_4096_ _1133_ _0868_ _1141_ _0079_ VGND VGND VPWR VPWR _1237_ sky130_fd_sc_hd__a22o_1
X_3047_ _0161_ _0162_ VGND VGND VPWR VPWR _0163_ sky130_fd_sc_hd__nor2_1
XFILLER_0_77_233 VGND VGND VPWR VPWR sky130_fd_sc_hd__fill_1
X_3949_ _1067_ _1077_ VGND VGND VPWR VPWR _1078_ sky130_fd_sc_hd__xnor2_1
XFILLER_0_45_163 VGND VGND VPWR VPWR sky130_fd_sc_hd__decap_4
XFILLER_0_73_461 VGND VGND VPWR VPWR sky130_fd_sc_hd__fill_2
XFILLER_0_18_388 VPWR VGND VPWR VGND sky130_ef_sc_hd__decap_12
XFILLER_0_33_325 VGND VGND VPWR VPWR sky130_fd_sc_hd__fill_1
XFILLER_0_68_222 VPWR VGND VPWR VGND sky130_ef_sc_hd__decap_12
XFILLER_0_56_439 VPWR VGND VPWR VGND sky130_ef_sc_hd__decap_12
XFILLER_0_68_277 VGND VGND VPWR VPWR sky130_fd_sc_hd__fill_1
XFILLER_0_36_141 VGND VGND VPWR VPWR sky130_fd_sc_hd__decap_3
XFILLER_0_51_166 VGND VGND VPWR VPWR sky130_fd_sc_hd__fill_2
XFILLER_0_19_55 VGND VGND VPWR VPWR sky130_fd_sc_hd__fill_1
X_2280_ net47 _1495_ _1493_ add_tmp\[1\] _1500_ VGND VGND VPWR VPWR _0003_ sky130_fd_sc_hd__o221a_1
XFILLER_0_47_417 VPWR VGND VPWR VGND sky130_ef_sc_hd__decap_12
XFILLER_0_74_203 VGND VGND VPWR VPWR sky130_fd_sc_hd__decap_8
X_3803_ _0916_ _0917_ _0913_ net123 VGND VGND VPWR VPWR _0920_ sky130_fd_sc_hd__a211o_1
X_3734_ _0291_ _0245_ VGND VGND VPWR VPWR _0845_ sky130_fd_sc_hd__nand2_1
XFILLER_0_70_431 VPWR VGND VPWR VGND sky130_ef_sc_hd__decap_12
X_3665_ _0685_ _0693_ VGND VGND VPWR VPWR _0774_ sky130_fd_sc_hd__nand2_1
XFILLER_0_2_230 VGND VGND VPWR VPWR sky130_fd_sc_hd__decap_3
X_2616_ _1660_ VGND VGND VPWR VPWR _1796_ sky130_fd_sc_hd__clkbuf_2
X_3596_ _0703_ _0704_ _0705_ VGND VGND VPWR VPWR _0706_ sky130_fd_sc_hd__a21oi_1
XFILLER_0_2_296 VGND VGND VPWR VPWR sky130_fd_sc_hd__decap_4
X_2547_ net11 VGND VGND VPWR VPWR _1729_ sky130_fd_sc_hd__buf_6
X_2478_ _1663_ VGND VGND VPWR VPWR _1664_ sky130_fd_sc_hd__clkbuf_2
XFILLER_0_55_3 VGND VGND VPWR VPWR sky130_fd_sc_hd__decap_8
XFILLER_0_76_83 VGND VGND VPWR VPWR sky130_fd_sc_hd__fill_1
X_4217_ _1332_ _1338_ _1336_ VGND VGND VPWR VPWR _1367_ sky130_fd_sc_hd__o21ai_1
X_4148_ _1283_ _1292_ VGND VGND VPWR VPWR _1293_ sky130_fd_sc_hd__xor2_1
X_4079_ _1207_ _1218_ VGND VGND VPWR VPWR _1219_ sky130_fd_sc_hd__xnor2_1
XFILLER_0_38_406 VGND VGND VPWR VPWR sky130_fd_sc_hd__decap_6
XFILLER_0_38_439 VGND VGND VPWR VPWR sky130_fd_sc_hd__fill_1
XFILLER_0_18_141 VGND VGND VPWR VPWR sky130_fd_sc_hd__fill_2
XFILLER_0_14_380 VPWR VGND VPWR VGND sky130_ef_sc_hd__decap_12
XFILLER_0_29_417 VPWR VGND VPWR VGND sky130_ef_sc_hd__decap_12
XFILLER_0_12_328 VPWR VGND VPWR VGND sky130_ef_sc_hd__decap_12
XFILLER_0_24_155 VGND VGND VPWR VPWR sky130_fd_sc_hd__decap_6
X_3450_ _1938_ _0165_ _0250_ _1868_ VGND VGND VPWR VPWR _0562_ sky130_fd_sc_hd__a22o_1
X_3381_ _0492_ _0493_ VGND VGND VPWR VPWR _0494_ sky130_fd_sc_hd__xnor2_1
X_2401_ _1427_ _1594_ _1425_ VGND VGND VPWR VPWR _1600_ sky130_fd_sc_hd__a21bo_1
X_2332_ _1543_ add_tmp\[10\] _1522_ VGND VGND VPWR VPWR _1544_ sky130_fd_sc_hd__mux2_1
X_4002_ _1132_ _1134_ VGND VGND VPWR VPWR _1136_ sky130_fd_sc_hd__nor2_1
X_2263_ _1483_ _1486_ VGND VGND VPWR VPWR _0000_ sky130_fd_sc_hd__nor2_1
X_2194_ _0875_ _1406_ _1414_ _1404_ VGND VGND VPWR VPWR _1418_ sky130_fd_sc_hd__a211o_1
XFILLER_0_62_41 VGND VGND VPWR VPWR sky130_fd_sc_hd__decap_8
X_3717_ _1691_ _0824_ _0825_ _0826_ VGND VGND VPWR VPWR _0058_ sky130_fd_sc_hd__a31o_1
X_3648_ _0112_ VGND VGND VPWR VPWR _0757_ sky130_fd_sc_hd__buf_1
XFILLER_0_30_158 VPWR VGND VPWR VGND sky130_ef_sc_hd__decap_12
X_3579_ _0687_ _0688_ VGND VGND VPWR VPWR _0689_ sky130_fd_sc_hd__nor2_1
XFILLER_0_11_361 VPWR VGND VPWR VGND sky130_ef_sc_hd__decap_12
Xhold57 add_tmp\[0\] VGND VGND VPWR VPWR net130 sky130_fd_sc_hd__dlygate4sd3_1
Xhold68 add_tmp\[21\] VGND VGND VPWR VPWR net141 sky130_fd_sc_hd__dlygate4sd3_1
XFILLER_0_19_461 VGND VGND VPWR VPWR sky130_fd_sc_hd__fill_2
XFILLER_0_21_103 VGND VGND VPWR VPWR sky130_fd_sc_hd__decap_8
XFILLER_0_21_136 VGND VGND VPWR VPWR sky130_fd_sc_hd__decap_4
XTAP_309 VGND VPWR sky130_fd_sc_hd__tapvpwrvgnd_1
XFILLER_0_16_67 VPWR VGND VPWR VGND sky130_ef_sc_hd__decap_12
XFILLER_0_29_214 VGND VGND VPWR VPWR sky130_fd_sc_hd__decap_3
X_2950_ _1983_ _1982_ VGND VGND VPWR VPWR _2125_ sky130_fd_sc_hd__and2_1
XFILLER_0_69_383 VGND VGND VPWR VPWR sky130_fd_sc_hd__decap_8
X_2881_ _2043_ _2031_ _2032_ VGND VGND VPWR VPWR _2056_ sky130_fd_sc_hd__nand3_1
XFILLER_0_44_228 VGND VGND VPWR VPWR sky130_fd_sc_hd__fill_1
XFILLER_0_44_239 VGND VGND VPWR VPWR sky130_fd_sc_hd__decap_4
XFILLER_0_4_303 VGND VGND VPWR VPWR sky130_fd_sc_hd__decap_4
XFILLER_0_4_347 VGND VGND VPWR VPWR sky130_fd_sc_hd__fill_1
XFILLER_0_52_250 VGND VGND VPWR VPWR sky130_fd_sc_hd__fill_2
XFILLER_0_52_261 VPWR VGND VPWR VGND sky130_ef_sc_hd__decap_12
XFILLER_0_12_114 VGND VGND VPWR VPWR sky130_fd_sc_hd__decap_3
X_3502_ _0108_ _0082_ _0610_ _0611_ VGND VGND VPWR VPWR _0613_ sky130_fd_sc_hd__a22oi_2
X_3433_ _0447_ _0450_ VGND VGND VPWR VPWR _0545_ sky130_fd_sc_hd__nand2_1
X_3364_ _1680_ _0476_ VGND VGND VPWR VPWR _0477_ sky130_fd_sc_hd__nand2_1
X_2315_ _1485_ _1529_ VGND VGND VPWR VPWR _1530_ sky130_fd_sc_hd__nor2_1
X_3295_ _0396_ _0397_ _0408_ VGND VGND VPWR VPWR _0409_ sky130_fd_sc_hd__a21oi_1
X_2246_ _1452_ _1455_ _1466_ _1469_ VGND VGND VPWR VPWR _1470_ sky130_fd_sc_hd__a211o_1
XFILLER_0_18_3 VGND VGND VPWR VPWR sky130_fd_sc_hd__fill_1
X_2177_ net40 add_tmp\[13\] VGND VGND VPWR VPWR _1362_ sky130_fd_sc_hd__nand2_1
XFILLER_0_73_51 VGND VGND VPWR VPWR sky130_fd_sc_hd__decap_4
XFILLER_0_7_141 VGND VGND VPWR VPWR sky130_fd_sc_hd__fill_2
XFILLER_0_35_206 VGND VGND VPWR VPWR sky130_fd_sc_hd__decap_6
Xoutput36 net36 VGND VGND VPWR VPWR out_acc[0] sky130_fd_sc_hd__clkbuf_4
Xoutput47 net47 VGND VGND VPWR VPWR out_acc[1] sky130_fd_sc_hd__clkbuf_4
Xoutput58 net58 VGND VGND VPWR VPWR out_acc[2] sky130_fd_sc_hd__clkbuf_4
Xoutput69 net69 VGND VGND VPWR VPWR out_acc[7] sky130_fd_sc_hd__clkbuf_4
XFILLER_0_58_309 VGND VGND VPWR VPWR sky130_fd_sc_hd__decap_3
XPHY_120 VGND VGND VPWR VPWR sky130_fd_sc_hd__decap_3
XPHY_131 VGND VGND VPWR VPWR sky130_fd_sc_hd__decap_3
XPHY_142 VGND VGND VPWR VPWR sky130_fd_sc_hd__decap_3
XPHY_153 VGND VGND VPWR VPWR sky130_fd_sc_hd__decap_3
XFILLER_0_26_206 VGND VGND VPWR VPWR sky130_fd_sc_hd__decap_4
XFILLER_0_34_261 VGND VGND VPWR VPWR sky130_fd_sc_hd__decap_8
XFILLER_0_27_11 VGND VGND VPWR VPWR sky130_fd_sc_hd__fill_1
X_3080_ _0193_ _0194_ _1759_ _1938_ VGND VGND VPWR VPWR _0196_ sky130_fd_sc_hd__and4bb_1
XFILLER_0_76_139 VGND VGND VPWR VPWR sky130_fd_sc_hd__fill_1
XPHY_0 VGND VGND VPWR VPWR sky130_fd_sc_hd__decap_3
X_3982_ _0981_ _1050_ VGND VGND VPWR VPWR _1115_ sky130_fd_sc_hd__or2_1
XFILLER_0_9_428 VPWR VGND VPWR VGND sky130_ef_sc_hd__decap_12
X_2933_ _2084_ _2106_ _2107_ VGND VGND VPWR VPWR _2108_ sky130_fd_sc_hd__and3_1
XFILLER_0_17_239 VGND VGND VPWR VPWR sky130_fd_sc_hd__fill_1
X_2864_ _2038_ _2039_ VGND VGND VPWR VPWR _2040_ sky130_fd_sc_hd__nor2_1
XFILLER_0_72_345 VGND VGND VPWR VPWR sky130_fd_sc_hd__decap_8
X_2795_ _1891_ _1906_ _1971_ VGND VGND VPWR VPWR _1972_ sky130_fd_sc_hd__o21ai_1
XFILLER_0_4_177 VPWR VGND VPWR VGND sky130_ef_sc_hd__decap_12
XFILLER_0_40_286 VPWR VGND VPWR VGND sky130_ef_sc_hd__decap_12
X_3416_ _0438_ _0439_ _0440_ VGND VGND VPWR VPWR _0528_ sky130_fd_sc_hd__and3_1
X_3347_ _0085_ VGND VGND VPWR VPWR _0460_ sky130_fd_sc_hd__buf_2
XTAP_640 VGND VPWR sky130_fd_sc_hd__tapvpwrvgnd_1
XTAP_651 VGND VPWR sky130_fd_sc_hd__tapvpwrvgnd_1
XTAP_662 VGND VPWR sky130_fd_sc_hd__tapvpwrvgnd_1
XTAP_673 VGND VPWR sky130_fd_sc_hd__tapvpwrvgnd_1
XTAP_684 VGND VPWR sky130_fd_sc_hd__tapvpwrvgnd_1
XTAP_695 VGND VPWR sky130_fd_sc_hd__tapvpwrvgnd_1
X_3278_ _0389_ _0390_ _0387_ _0388_ VGND VGND VPWR VPWR _0392_ sky130_fd_sc_hd__a211o_1
X_2229_ _1449_ _1439_ _1438_ VGND VGND VPWR VPWR _1453_ sky130_fd_sc_hd__a21o_1
XFILLER_0_75_150 VGND VGND VPWR VPWR sky130_fd_sc_hd__decap_8
XFILLER_0_31_253 VGND VGND VPWR VPWR sky130_fd_sc_hd__fill_1
XFILLER_0_7_3 VPWR VGND VPWR VGND sky130_ef_sc_hd__decap_12
XFILLER_0_13_57 VGND VGND VPWR VPWR sky130_fd_sc_hd__decap_8
XFILLER_0_54_301 VGND VGND VPWR VPWR sky130_fd_sc_hd__decap_6
XFILLER_0_14_209 VGND VGND VPWR VPWR sky130_fd_sc_hd__decap_6
XFILLER_0_22_231 VPWR VGND VPWR VGND sky130_ef_sc_hd__decap_12
XFILLER_0_22_253 VPWR VGND VPWR VGND sky130_ef_sc_hd__decap_12
X_2580_ _1760_ _1758_ VGND VGND VPWR VPWR _1761_ sky130_fd_sc_hd__nor2_2
X_4250_ _1125_ _1303_ _1375_ VGND VGND VPWR VPWR _1402_ sky130_fd_sc_hd__mux2_1
XFILLER_0_1_169 VPWR VGND VPWR VGND sky130_ef_sc_hd__decap_12
X_4181_ _1322_ _1327_ _1675_ VGND VGND VPWR VPWR _1329_ sky130_fd_sc_hd__a21oi_1
X_3201_ _0315_ _0145_ _0231_ VGND VGND VPWR VPWR _0316_ sky130_fd_sc_hd__o21ba_1
X_3132_ _0244_ _0246_ VGND VGND VPWR VPWR _0247_ sky130_fd_sc_hd__or2_4
XFILLER_0_38_65 VGND VGND VPWR VPWR sky130_fd_sc_hd__decap_8
X_3063_ _0177_ _0174_ _0175_ VGND VGND VPWR VPWR _0179_ sky130_fd_sc_hd__nor3_2
XFILLER_0_54_53 VPWR VGND VPWR VGND sky130_ef_sc_hd__decap_12
XFILLER_0_9_225 VPWR VGND VPWR VGND sky130_ef_sc_hd__decap_12
XFILLER_0_9_214 VGND VGND VPWR VPWR sky130_fd_sc_hd__decap_4
X_3965_ _0761_ _0744_ _1018_ VGND VGND VPWR VPWR _1096_ sky130_fd_sc_hd__and3b_1
X_3896_ _1019_ _1020_ VGND VGND VPWR VPWR _1021_ sky130_fd_sc_hd__xnor2_1
X_2916_ _1685_ _1942_ VGND VGND VPWR VPWR _2091_ sky130_fd_sc_hd__and2_1
X_2847_ _2019_ _2020_ _2021_ VGND VGND VPWR VPWR _2023_ sky130_fd_sc_hd__a21o_1
XFILLER_0_60_304 VGND VGND VPWR VPWR sky130_fd_sc_hd__decap_4
XFILLER_0_5_442 VGND VGND VPWR VPWR sky130_fd_sc_hd__decap_6
XFILLER_0_45_389 VGND VGND VPWR VPWR sky130_fd_sc_hd__decap_3
XFILLER_0_72_186 VGND VGND VPWR VPWR sky130_fd_sc_hd__decap_8
XFILLER_0_13_242 VGND VGND VPWR VPWR sky130_fd_sc_hd__decap_8
X_2778_ _1842_ VGND VGND VPWR VPWR _1955_ sky130_fd_sc_hd__clkbuf_2
XFILLER_0_13_275 VGND VGND VPWR VPWR sky130_fd_sc_hd__decap_4
XTAP_470 VGND VPWR sky130_fd_sc_hd__tapvpwrvgnd_1
XTAP_481 VGND VPWR sky130_fd_sc_hd__tapvpwrvgnd_1
XTAP_492 VGND VPWR sky130_fd_sc_hd__tapvpwrvgnd_1
XFILLER_0_55_109 VGND VGND VPWR VPWR sky130_fd_sc_hd__decap_3
XFILLER_0_48_194 VGND VGND VPWR VPWR sky130_fd_sc_hd__fill_2
X_3750_ _0205_ _0858_ _0860_ _0861_ VGND VGND VPWR VPWR _0862_ sky130_fd_sc_hd__nand4_2
XFILLER_0_27_334 VGND VGND VPWR VPWR sky130_fd_sc_hd__fill_2
XFILLER_0_54_120 VGND VGND VPWR VPWR sky130_fd_sc_hd__fill_1
X_2701_ _1722_ VGND VGND VPWR VPWR _1879_ sky130_fd_sc_hd__clkbuf_2
X_3681_ _1892_ _0530_ _0779_ _0709_ VGND VGND VPWR VPWR _0790_ sky130_fd_sc_hd__a22o_1
XFILLER_0_54_175 VGND VGND VPWR VPWR sky130_fd_sc_hd__decap_4
XFILLER_0_54_197 VGND VGND VPWR VPWR sky130_fd_sc_hd__decap_4
X_2632_ _1808_ _1810_ _1811_ VGND VGND VPWR VPWR _1812_ sky130_fd_sc_hd__o21ai_1
XFILLER_0_2_445 VPWR VGND VPWR VGND sky130_ef_sc_hd__decap_12
X_2563_ net14 VGND VGND VPWR VPWR _1744_ sky130_fd_sc_hd__buf_4
XFILLER_0_49_20 VPWR VGND VPWR VGND sky130_ef_sc_hd__decap_12
X_4302_ clknet_3_6__leaf_clk _0047_ net35 VGND VGND VPWR VPWR add_tmp\[9\] sky130_fd_sc_hd__dfrtp_1
X_4233_ _1382_ _1384_ VGND VGND VPWR VPWR _1385_ sky130_fd_sc_hd__xor2_1
X_2494_ net11 VGND VGND VPWR VPWR _1678_ sky130_fd_sc_hd__clkbuf_2
XFILLER_0_57_7 VGND VGND VPWR VPWR sky130_fd_sc_hd__decap_4
XFILLER_0_10_289 VGND VGND VPWR VPWR sky130_fd_sc_hd__decap_4
X_4164_ _1306_ _1310_ VGND VGND VPWR VPWR _1311_ sky130_fd_sc_hd__xor2_1
X_4095_ _1235_ VGND VGND VPWR VPWR _1236_ sky130_fd_sc_hd__buf_1
X_3115_ _0229_ _0230_ VGND VGND VPWR VPWR _0231_ sky130_fd_sc_hd__nand2_1
X_3046_ _1668_ _1661_ _0079_ _0159_ VGND VGND VPWR VPWR _0162_ sky130_fd_sc_hd__and4_1
XFILLER_0_65_96 VPWR VGND VPWR VGND sky130_ef_sc_hd__decap_12
XFILLER_0_77_223 VGND VGND VPWR VPWR sky130_fd_sc_hd__fill_1
XFILLER_0_77_289 VGND VGND VPWR VPWR sky130_fd_sc_hd__fill_1
XFILLER_0_45_120 VGND VGND VPWR VPWR sky130_fd_sc_hd__decap_4
XFILLER_0_18_345 VPWR VGND VPWR VGND sky130_ef_sc_hd__decap_12
X_3948_ _1075_ _1076_ VGND VGND VPWR VPWR _1077_ sky130_fd_sc_hd__nand2_1
XFILLER_0_45_142 VGND VGND VPWR VPWR sky130_fd_sc_hd__decap_3
X_3879_ _1000_ _1001_ _0874_ VGND VGND VPWR VPWR _1002_ sky130_fd_sc_hd__a21o_1
XFILLER_0_33_337 VGND VGND VPWR VPWR sky130_fd_sc_hd__decap_4
XFILLER_0_41_381 VGND VGND VPWR VPWR sky130_fd_sc_hd__decap_8
XFILLER_0_68_234 VGND VGND VPWR VPWR sky130_fd_sc_hd__decap_4
XFILLER_0_56_429 VGND VGND VPWR VPWR sky130_fd_sc_hd__fill_1
XFILLER_0_64_462 VGND VGND VPWR VPWR sky130_fd_sc_hd__fill_1
XFILLER_0_24_337 VGND VGND VPWR VPWR sky130_fd_sc_hd__decap_6
XFILLER_0_36_175 VGND VGND VPWR VPWR sky130_fd_sc_hd__decap_8
XFILLER_0_32_381 VPWR VGND VPWR VGND sky130_ef_sc_hd__decap_12
XFILLER_0_19_67 VGND VGND VPWR VPWR sky130_fd_sc_hd__decap_4
XFILLER_0_35_11 VGND VGND VPWR VPWR sky130_fd_sc_hd__fill_1
XFILLER_0_59_201 VGND VGND VPWR VPWR sky130_fd_sc_hd__decap_6
XFILLER_0_59_256 VGND VGND VPWR VPWR sky130_fd_sc_hd__decap_3
XFILLER_0_47_429 VGND VGND VPWR VPWR sky130_fd_sc_hd__decap_8
X_3802_ _0913_ net123 _0916_ _0917_ VGND VGND VPWR VPWR _0919_ sky130_fd_sc_hd__o211ai_4
XFILLER_0_51_54 VGND VGND VPWR VPWR sky130_fd_sc_hd__fill_2
XFILLER_0_27_142 VGND VGND VPWR VPWR sky130_fd_sc_hd__fill_2
XFILLER_0_74_259 VGND VGND VPWR VPWR sky130_fd_sc_hd__decap_6
X_3733_ _0841_ _0843_ VGND VGND VPWR VPWR _0844_ sky130_fd_sc_hd__nor2_1
XFILLER_0_70_410 VGND VGND VPWR VPWR sky130_fd_sc_hd__decap_4
XFILLER_0_15_337 VPWR VGND VPWR VGND sky130_ef_sc_hd__decap_12
X_3664_ _0770_ _0771_ _0753_ VGND VGND VPWR VPWR _0773_ sky130_fd_sc_hd__a21o_1
XFILLER_0_70_443 VPWR VGND VPWR VGND sky130_ef_sc_hd__decap_12
X_2615_ _1790_ _1791_ _1792_ VGND VGND VPWR VPWR _1795_ sky130_fd_sc_hd__a21oi_1
XFILLER_0_42_167 VGND VGND VPWR VPWR sky130_fd_sc_hd__fill_2
XFILLER_0_42_178 VGND VGND VPWR VPWR sky130_fd_sc_hd__decap_4
XFILLER_0_2_253 VGND VGND VPWR VPWR sky130_fd_sc_hd__decap_3
X_3595_ _0631_ _0632_ VGND VGND VPWR VPWR _0705_ sky130_fd_sc_hd__nand2_1
X_2546_ _1725_ _1726_ _1721_ _1727_ VGND VGND VPWR VPWR _1728_ sky130_fd_sc_hd__nand4_2
X_2477_ _1662_ VGND VGND VPWR VPWR _1663_ sky130_fd_sc_hd__dlymetal6s2s_1
X_4216_ _1366_ VGND VGND VPWR VPWR _0067_ sky130_fd_sc_hd__clkbuf_1
XFILLER_0_48_3 VGND VGND VPWR VPWR sky130_fd_sc_hd__decap_8
X_4147_ _0869_ _1290_ _1291_ VGND VGND VPWR VPWR _1292_ sky130_fd_sc_hd__a21o_1
X_4078_ _1216_ _1217_ VGND VGND VPWR VPWR _1218_ sky130_fd_sc_hd__or2_1
X_3029_ net77 net152 _2119_ VGND VGND VPWR VPWR _0146_ sky130_fd_sc_hd__a21oi_2
XFILLER_0_18_120 VGND VGND VPWR VPWR sky130_fd_sc_hd__decap_4
XFILLER_0_65_259 VGND VGND VPWR VPWR sky130_fd_sc_hd__decap_3
XFILLER_0_18_164 VGND VGND VPWR VPWR sky130_fd_sc_hd__decap_8
XFILLER_0_14_392 VPWR VGND VPWR VGND sky130_ef_sc_hd__decap_12
XFILLER_0_29_429 VGND VGND VPWR VPWR sky130_fd_sc_hd__fill_2
XFILLER_0_56_215 VPWR VGND VPWR VGND sky130_ef_sc_hd__decap_12
XFILLER_0_52_421 VPWR VGND VPWR VGND sky130_ef_sc_hd__decap_12
XFILLER_0_21_57 VPWR VGND VPWR VGND sky130_ef_sc_hd__decap_12
XFILLER_0_64_281 VGND VGND VPWR VPWR sky130_fd_sc_hd__fill_1
XFILLER_0_24_178 VGND VGND VPWR VPWR sky130_fd_sc_hd__fill_1
XFILLER_0_24_189 VGND VGND VPWR VPWR sky130_fd_sc_hd__decap_6
X_2400_ _1423_ _1424_ VGND VGND VPWR VPWR _1599_ sky130_fd_sc_hd__nand2_1
X_3380_ _1670_ _0403_ VGND VGND VPWR VPWR _0493_ sky130_fd_sc_hd__nor2_2
X_2331_ _1542_ _1319_ VGND VGND VPWR VPWR _1543_ sky130_fd_sc_hd__xor2_1
X_2262_ _1485_ VGND VGND VPWR VPWR _1486_ sky130_fd_sc_hd__buf_2
X_4001_ _1131_ _0157_ _0858_ _1133_ VGND VGND VPWR VPWR _1134_ sky130_fd_sc_hd__and4_1
XFILLER_0_34_9 VPWR VGND VPWR VGND sky130_ef_sc_hd__decap_12
X_2193_ net46 add_tmp\[19\] VGND VGND VPWR VPWR _1417_ sky130_fd_sc_hd__nor2_1
XFILLER_0_1_12 VPWR VGND VPWR VGND sky130_ef_sc_hd__decap_12
XFILLER_0_1_78 VGND VGND VPWR VPWR sky130_fd_sc_hd__decap_4
XFILLER_0_7_323 VPWR VGND VPWR VGND sky130_ef_sc_hd__decap_12
XFILLER_0_15_101 VGND VGND VPWR VPWR sky130_fd_sc_hd__decap_8
XFILLER_0_55_281 VPWR VGND VPWR VGND sky130_ef_sc_hd__decap_12
X_3716_ add_tmp\[20\] _1654_ VGND VGND VPWR VPWR _0826_ sky130_fd_sc_hd__and2_1
XFILLER_0_15_167 VGND VGND VPWR VPWR sky130_fd_sc_hd__fill_1
XFILLER_0_30_104 VGND VGND VPWR VPWR sky130_fd_sc_hd__fill_2
XFILLER_0_70_262 VGND VGND VPWR VPWR sky130_fd_sc_hd__fill_1
XFILLER_0_11_90 VPWR VGND VPWR VGND sky130_ef_sc_hd__decap_12
X_3647_ _0755_ _0376_ _0681_ _0682_ VGND VGND VPWR VPWR _0756_ sky130_fd_sc_hd__and4_1
X_3578_ _1929_ _0107_ _0077_ _0470_ VGND VGND VPWR VPWR _0688_ sky130_fd_sc_hd__and4_1
X_2529_ _1675_ VGND VGND VPWR VPWR _1712_ sky130_fd_sc_hd__clkbuf_2
XFILLER_0_11_373 VGND VGND VPWR VPWR sky130_fd_sc_hd__fill_1
Xhold58 add_tmp\[7\] VGND VGND VPWR VPWR net131 sky130_fd_sc_hd__dlygate4sd3_1
XFILLER_0_38_204 VPWR VGND VPWR VGND sky130_ef_sc_hd__decap_12
XFILLER_0_34_410 VGND VGND VPWR VPWR sky130_fd_sc_hd__decap_3
XFILLER_0_46_270 VGND VGND VPWR VPWR sky130_fd_sc_hd__fill_2
XFILLER_0_34_421 VPWR VGND VPWR VGND sky130_ef_sc_hd__decap_12
XFILLER_0_21_148 VGND VGND VPWR VPWR sky130_fd_sc_hd__decap_6
XFILLER_0_29_248 VGND VGND VPWR VPWR sky130_fd_sc_hd__fill_2
XFILLER_0_32_45 VGND VGND VPWR VPWR sky130_fd_sc_hd__decap_4
X_2880_ _2046_ _2047_ _1994_ VGND VGND VPWR VPWR _2055_ sky130_fd_sc_hd__and3b_1
X_3501_ _0107_ _2061_ _0610_ _0611_ VGND VGND VPWR VPWR _0612_ sky130_fd_sc_hd__and4_2
XFILLER_0_52_273 VGND VGND VPWR VPWR sky130_fd_sc_hd__decap_4
X_3432_ _0540_ _0541_ _0542_ VGND VGND VPWR VPWR _0544_ sky130_fd_sc_hd__a21o_1
X_3363_ net24 VGND VGND VPWR VPWR _0476_ sky130_fd_sc_hd__clkbuf_2
XFILLER_0_20_181 VPWR VGND VPWR VGND sky130_ef_sc_hd__decap_12
X_2314_ _1265_ _1049_ _1254_ VGND VGND VPWR VPWR _1529_ sky130_fd_sc_hd__o21a_1
X_3294_ _0406_ _0407_ VGND VGND VPWR VPWR _0408_ sky130_fd_sc_hd__and2_1
X_2245_ _1467_ _1468_ VGND VGND VPWR VPWR _1469_ sky130_fd_sc_hd__nand2_1
X_2176_ _1016_ _1319_ _1330_ _1340_ VGND VGND VPWR VPWR _1351_ sky130_fd_sc_hd__a211oi_2
XFILLER_0_16_421 VGND VGND VPWR VPWR sky130_fd_sc_hd__fill_2
XFILLER_0_31_402 VGND VGND VPWR VPWR sky130_fd_sc_hd__fill_2
XFILLER_0_31_446 VGND VGND VPWR VPWR sky130_fd_sc_hd__fill_2
Xoutput37 net37 VGND VGND VPWR VPWR out_acc[10] sky130_fd_sc_hd__clkbuf_4
Xoutput48 net48 VGND VGND VPWR VPWR out_acc[20] sky130_fd_sc_hd__clkbuf_4
XFILLER_0_11_192 VPWR VGND VPWR VGND sky130_ef_sc_hd__decap_12
Xoutput59 net59 VGND VGND VPWR VPWR out_acc[30] sky130_fd_sc_hd__clkbuf_4
XPHY_110 VGND VGND VPWR VPWR sky130_fd_sc_hd__decap_3
XPHY_121 VGND VGND VPWR VPWR sky130_fd_sc_hd__decap_3
XPHY_132 VGND VGND VPWR VPWR sky130_fd_sc_hd__decap_3
XPHY_143 VGND VGND VPWR VPWR sky130_fd_sc_hd__decap_3
XPHY_154 VGND VGND VPWR VPWR sky130_fd_sc_hd__decap_3
XFILLER_0_19_281 VGND VGND VPWR VPWR sky130_fd_sc_hd__decap_8
XFILLER_0_22_435 VPWR VGND VPWR VGND sky130_ef_sc_hd__decap_12
X_3981_ _1111_ _1112_ VGND VGND VPWR VPWR _1113_ sky130_fd_sc_hd__or2b_1
XPHY_1 VGND VGND VPWR VPWR sky130_fd_sc_hd__decap_3
X_2932_ _2103_ _2104_ _2105_ VGND VGND VPWR VPWR _2107_ sky130_fd_sc_hd__a21o_1
X_2863_ _1668_ _1796_ _1975_ _2037_ VGND VGND VPWR VPWR _2039_ sky130_fd_sc_hd__and4_1
XFILLER_0_25_251 VGND VGND VPWR VPWR sky130_fd_sc_hd__decap_3
X_2794_ net116 _1905_ VGND VGND VPWR VPWR _1971_ sky130_fd_sc_hd__nand2_1
XFILLER_0_72_368 VPWR VGND VPWR VGND sky130_ef_sc_hd__decap_12
XFILLER_0_7_33 VGND VGND VPWR VPWR sky130_fd_sc_hd__fill_1
XFILLER_0_4_189 VGND VGND VPWR VPWR sky130_fd_sc_hd__decap_6
XFILLER_0_68_41 VGND VGND VPWR VPWR sky130_fd_sc_hd__fill_1
X_3415_ _0516_ _0526_ VGND VGND VPWR VPWR _0527_ sky130_fd_sc_hd__xnor2_1
XFILLER_0_0_373 VGND VGND VPWR VPWR sky130_fd_sc_hd__fill_2
XFILLER_0_40_298 VGND VGND VPWR VPWR sky130_fd_sc_hd__decap_8
XFILLER_0_68_85 VPWR VGND VPWR VGND sky130_ef_sc_hd__decap_12
XTAP_630 VGND VPWR sky130_fd_sc_hd__tapvpwrvgnd_1
XTAP_641 VGND VPWR sky130_fd_sc_hd__tapvpwrvgnd_1
XTAP_652 VGND VPWR sky130_fd_sc_hd__tapvpwrvgnd_1
X_3346_ _0352_ _0360_ _0359_ VGND VGND VPWR VPWR _0459_ sky130_fd_sc_hd__a21o_1
XTAP_663 VGND VPWR sky130_fd_sc_hd__tapvpwrvgnd_1
XTAP_674 VGND VPWR sky130_fd_sc_hd__tapvpwrvgnd_1
XTAP_685 VGND VPWR sky130_fd_sc_hd__tapvpwrvgnd_1
XFILLER_0_30_3 VGND VGND VPWR VPWR sky130_fd_sc_hd__fill_1
XTAP_696 VGND VPWR sky130_fd_sc_hd__tapvpwrvgnd_1
X_3277_ _0387_ _0388_ _0389_ _0390_ VGND VGND VPWR VPWR _0391_ sky130_fd_sc_hd__o211ai_1
X_2228_ _1433_ _1437_ _1448_ _1451_ VGND VGND VPWR VPWR _1452_ sky130_fd_sc_hd__a211o_1
X_2159_ _1103_ _1146_ _1157_ VGND VGND VPWR VPWR _1168_ sky130_fd_sc_hd__o21a_1
XFILLER_0_48_321 VGND VGND VPWR VPWR sky130_fd_sc_hd__decap_4
XFILLER_0_75_184 VGND VGND VPWR VPWR sky130_fd_sc_hd__decap_3
XFILLER_0_16_251 VGND VGND VPWR VPWR sky130_fd_sc_hd__fill_1
XFILLER_0_31_221 VGND VGND VPWR VPWR sky130_fd_sc_hd__decap_3
XFILLER_0_71_390 VGND VGND VPWR VPWR sky130_fd_sc_hd__fill_2
XFILLER_0_39_310 VPWR VGND VPWR VGND sky130_ef_sc_hd__decap_12
XFILLER_0_13_25 VPWR VGND VPWR VGND sky130_ef_sc_hd__decap_12
XFILLER_0_54_335 VGND VGND VPWR VPWR sky130_fd_sc_hd__fill_1
XFILLER_0_22_243 VGND VGND VPWR VPWR sky130_fd_sc_hd__decap_8
XFILLER_0_22_265 VPWR VGND VPWR VGND sky130_ef_sc_hd__decap_12
X_4180_ _1322_ _1327_ VGND VGND VPWR VPWR _1328_ sky130_fd_sc_hd__or2_4
XFILLER_0_38_33 VGND VGND VPWR VPWR sky130_fd_sc_hd__decap_3
XFILLER_0_38_44 VGND VGND VPWR VPWR sky130_fd_sc_hd__decap_8
X_3200_ net78 VGND VGND VPWR VPWR _0315_ sky130_fd_sc_hd__inv_2
X_3131_ _1661_ _0245_ _0241_ _0243_ VGND VGND VPWR VPWR _0246_ sky130_fd_sc_hd__a22oi_1
X_3062_ _0174_ _0175_ _0177_ VGND VGND VPWR VPWR _0178_ sky130_fd_sc_hd__o21a_1
XFILLER_0_54_65 VPWR VGND VPWR VGND sky130_ef_sc_hd__decap_12
XFILLER_0_77_449 VGND VGND VPWR VPWR sky130_fd_sc_hd__fill_2
XFILLER_0_9_248 VGND VGND VPWR VPWR sky130_fd_sc_hd__fill_2
XFILLER_0_9_237 VGND VGND VPWR VPWR sky130_fd_sc_hd__decap_8
X_3964_ _1058_ _1030_ _1093_ VGND VGND VPWR VPWR _1095_ sky130_fd_sc_hd__a21oi_2
X_3895_ _0761_ _0245_ VGND VGND VPWR VPWR _1020_ sky130_fd_sc_hd__nand2_1
X_2915_ _2086_ _2089_ VGND VGND VPWR VPWR _2090_ sky130_fd_sc_hd__xnor2_2
XFILLER_0_70_75 VGND VGND VPWR VPWR sky130_fd_sc_hd__fill_1
X_2846_ _2019_ _2020_ _2021_ VGND VGND VPWR VPWR _2022_ sky130_fd_sc_hd__nand3_2
X_2777_ _1901_ _1904_ VGND VGND VPWR VPWR _1954_ sky130_fd_sc_hd__or2_4
XTAP_460 VGND VPWR sky130_fd_sc_hd__tapvpwrvgnd_1
XTAP_471 VGND VPWR sky130_fd_sc_hd__tapvpwrvgnd_1
XTAP_482 VGND VPWR sky130_fd_sc_hd__tapvpwrvgnd_1
XTAP_493 VGND VPWR sky130_fd_sc_hd__tapvpwrvgnd_1
X_3329_ _0438_ _0439_ _0440_ VGND VGND VPWR VPWR _0442_ sky130_fd_sc_hd__a21o_1
XFILLER_0_63_110 VGND VGND VPWR VPWR sky130_fd_sc_hd__fill_2
XFILLER_0_63_121 VPWR VGND VPWR VGND sky130_ef_sc_hd__decap_12
XFILLER_0_63_143 VGND VGND VPWR VPWR sky130_fd_sc_hd__fill_2
XFILLER_0_63_176 VGND VGND VPWR VPWR sky130_fd_sc_hd__decap_8
XFILLER_0_27_302 VGND VGND VPWR VPWR sky130_fd_sc_hd__decap_4
XFILLER_0_39_195 VGND VGND VPWR VPWR sky130_fd_sc_hd__fill_2
X_2700_ _1877_ _1837_ VGND VGND VPWR VPWR _1878_ sky130_fd_sc_hd__nand2_1
X_3680_ _0647_ _0710_ _0711_ _0649_ VGND VGND VPWR VPWR _0789_ sky130_fd_sc_hd__a31o_1
X_2631_ _1741_ _1768_ VGND VGND VPWR VPWR _1811_ sky130_fd_sc_hd__or2_1
X_2562_ _1720_ _1722_ net14 _1723_ VGND VGND VPWR VPWR _1743_ sky130_fd_sc_hd__a22o_1
XFILLER_0_10_235 VGND VGND VPWR VPWR sky130_fd_sc_hd__decap_8
XFILLER_0_10_224 VGND VGND VPWR VPWR sky130_fd_sc_hd__decap_8
X_4301_ clknet_3_6__leaf_clk _0046_ net35 VGND VGND VPWR VPWR add_tmp\[8\] sky130_fd_sc_hd__dfrtp_1
XFILLER_0_49_32 VGND VGND VPWR VPWR sky130_fd_sc_hd__fill_1
XFILLER_0_49_54 VGND VGND VPWR VPWR sky130_fd_sc_hd__fill_2
X_4232_ _1345_ _1348_ _1307_ VGND VGND VPWR VPWR _1384_ sky130_fd_sc_hd__a21bo_1
X_2493_ net135 _1656_ _1674_ _1677_ VGND VGND VPWR VPWR _0039_ sky130_fd_sc_hd__a22o_1
XFILLER_0_49_65 VGND VGND VPWR VPWR sky130_fd_sc_hd__decap_3
X_4163_ _1307_ _1309_ VGND VGND VPWR VPWR _1310_ sky130_fd_sc_hd__and2_1
X_4094_ _2064_ _1140_ VGND VGND VPWR VPWR _1235_ sky130_fd_sc_hd__nand2_1
X_3114_ _0226_ _0228_ net76 net84 VGND VGND VPWR VPWR _0230_ sky130_fd_sc_hd__a211o_1
X_3045_ _1669_ _0157_ _0160_ _1796_ VGND VGND VPWR VPWR _0161_ sky130_fd_sc_hd__a22oi_2
XFILLER_0_77_268 VPWR VGND VPWR VGND sky130_ef_sc_hd__decap_12
XFILLER_0_65_408 VPWR VGND VPWR VGND sky130_ef_sc_hd__decap_12
X_3947_ _1072_ _1073_ _1074_ VGND VGND VPWR VPWR _1076_ sky130_fd_sc_hd__a21o_1
XFILLER_0_18_357 VGND VGND VPWR VPWR sky130_fd_sc_hd__decap_4
XFILLER_0_73_441 VGND VGND VPWR VPWR sky130_fd_sc_hd__decap_6
X_3878_ _0999_ _0997_ _0998_ VGND VGND VPWR VPWR _1001_ sky130_fd_sc_hd__nand3_1
X_2829_ _1995_ _2004_ VGND VGND VPWR VPWR _2005_ sky130_fd_sc_hd__xnor2_2
XFILLER_0_5_295 VGND VGND VPWR VPWR sky130_fd_sc_hd__decap_3
XFILLER_0_41_393 VGND VGND VPWR VPWR sky130_fd_sc_hd__fill_1
XTAP_290 VGND VPWR sky130_fd_sc_hd__tapvpwrvgnd_1
XFILLER_0_49_460 VGND VGND VPWR VPWR sky130_fd_sc_hd__decap_3
XFILLER_0_56_419 VGND VGND VPWR VPWR sky130_fd_sc_hd__fill_1
XFILLER_0_51_113 VGND VGND VPWR VPWR sky130_fd_sc_hd__decap_6
XFILLER_0_51_179 VGND VGND VPWR VPWR sky130_fd_sc_hd__decap_3
XFILLER_0_32_393 VGND VGND VPWR VPWR sky130_fd_sc_hd__decap_8
XFILLER_0_19_57 VGND VGND VPWR VPWR sky130_fd_sc_hd__decap_3
Xclkbuf_3_7__f_clk clknet_0_clk VGND VGND VPWR VPWR clknet_3_7__leaf_clk sky130_fd_sc_hd__clkbuf_16
X_3801_ _0912_ _2064_ _0914_ _0915_ VGND VGND VPWR VPWR _0917_ sky130_fd_sc_hd__a22o_1
XFILLER_0_74_238 VGND VGND VPWR VPWR sky130_fd_sc_hd__decap_8
X_3732_ _0111_ _0277_ _0155_ _0158_ VGND VGND VPWR VPWR _0843_ sky130_fd_sc_hd__and4_1
XFILLER_0_15_349 VGND VGND VPWR VPWR sky130_fd_sc_hd__decap_8
X_3663_ _0753_ _0770_ _0771_ VGND VGND VPWR VPWR _0772_ sky130_fd_sc_hd__nand3_1
XFILLER_0_70_455 VGND VGND VPWR VPWR sky130_fd_sc_hd__decap_8
X_2614_ _1793_ VGND VGND VPWR VPWR _1794_ sky130_fd_sc_hd__buf_4
XFILLER_0_23_393 VPWR VGND VPWR VGND sky130_ef_sc_hd__decap_12
X_3594_ _0701_ _0702_ _0698_ VGND VGND VPWR VPWR _0704_ sky130_fd_sc_hd__a21o_1
X_2545_ net13 VGND VGND VPWR VPWR _1727_ sky130_fd_sc_hd__clkbuf_2
XFILLER_0_76_41 VPWR VGND VPWR VGND sky130_ef_sc_hd__decap_12
X_2476_ _1661_ VGND VGND VPWR VPWR _1662_ sky130_fd_sc_hd__dlymetal6s2s_1
XFILLER_0_76_85 VPWR VGND VPWR VGND sky130_ef_sc_hd__decap_12
X_4215_ add_tmp\[29\] _1365_ _1054_ VGND VGND VPWR VPWR _1366_ sky130_fd_sc_hd__mux2_4
X_4146_ _0869_ _0519_ _1289_ VGND VGND VPWR VPWR _1291_ sky130_fd_sc_hd__a21oi_1
X_4077_ _1208_ _1215_ VGND VGND VPWR VPWR _1217_ sky130_fd_sc_hd__nor2_1
X_3028_ _2119_ _0143_ _0144_ VGND VGND VPWR VPWR _0145_ sky130_fd_sc_hd__and3_1
XFILLER_0_65_205 VPWR VGND VPWR VGND sky130_ef_sc_hd__decap_12
XFILLER_0_46_441 VGND VGND VPWR VPWR sky130_fd_sc_hd__fill_1
XFILLER_0_65_249 VGND VGND VPWR VPWR sky130_fd_sc_hd__decap_4
XFILLER_0_61_411 VGND VGND VPWR VPWR sky130_fd_sc_hd__fill_1
XFILLER_0_33_146 VGND VGND VPWR VPWR sky130_fd_sc_hd__decap_8
XFILLER_0_56_227 VGND VGND VPWR VPWR sky130_fd_sc_hd__decap_4
XFILLER_0_56_249 VGND VGND VPWR VPWR sky130_fd_sc_hd__decap_3
XFILLER_0_71_219 VGND VGND VPWR VPWR sky130_fd_sc_hd__decap_4
XFILLER_0_21_69 VPWR VGND VPWR VGND sky130_ef_sc_hd__decap_12
XFILLER_0_24_113 VGND VGND VPWR VPWR sky130_fd_sc_hd__fill_1
XFILLER_0_52_433 VPWR VGND VPWR VGND sky130_ef_sc_hd__decap_12
X_2330_ _1340_ _1005_ VGND VGND VPWR VPWR _1542_ sky130_fd_sc_hd__nor2_1
X_2261_ clr_delay _1484_ VGND VGND VPWR VPWR _1485_ sky130_fd_sc_hd__or2_2
X_4000_ _0473_ VGND VGND VPWR VPWR _1133_ sky130_fd_sc_hd__dlymetal6s2s_1
XFILLER_0_46_11 VGND VGND VPWR VPWR sky130_fd_sc_hd__decap_3
XFILLER_0_46_66 VGND VGND VPWR VPWR sky130_fd_sc_hd__decap_8
X_2192_ _0897_ _0908_ _1393_ _1415_ VGND VGND VPWR VPWR _1416_ sky130_fd_sc_hd__or4_1
XFILLER_0_1_24 VPWR VGND VPWR VGND sky130_ef_sc_hd__decap_12
XFILLER_0_1_57 VGND VGND VPWR VPWR sky130_fd_sc_hd__decap_8
XFILLER_0_47_216 VGND VGND VPWR VPWR sky130_fd_sc_hd__decap_8
XFILLER_0_62_76 VGND VGND VPWR VPWR sky130_fd_sc_hd__decap_8
XFILLER_0_7_335 VGND VGND VPWR VPWR sky130_fd_sc_hd__fill_1
XFILLER_0_43_411 VGND VGND VPWR VPWR sky130_fd_sc_hd__fill_1
XFILLER_0_15_113 VGND VGND VPWR VPWR sky130_fd_sc_hd__decap_6
X_3715_ _0818_ _0823_ VGND VGND VPWR VPWR _0825_ sky130_fd_sc_hd__nand2_1
XFILLER_0_70_230 VGND VGND VPWR VPWR sky130_fd_sc_hd__fill_1
X_3646_ _0191_ VGND VGND VPWR VPWR _0755_ sky130_fd_sc_hd__buf_1
X_3577_ _0108_ _0078_ _0473_ _1997_ VGND VGND VPWR VPWR _0687_ sky130_fd_sc_hd__a22oi_1
XFILLER_0_60_3 VGND VGND VPWR VPWR sky130_fd_sc_hd__decap_4
X_2528_ _1690_ _1709_ _1675_ VGND VGND VPWR VPWR _1711_ sky130_fd_sc_hd__a21o_1
XFILLER_0_11_396 VGND VGND VPWR VPWR sky130_fd_sc_hd__decap_8
X_2459_ _1480_ _1481_ _1478_ _1479_ VGND VGND VPWR VPWR _1647_ sky130_fd_sc_hd__o211a_1
Xhold59 add_tmp\[11\] VGND VGND VPWR VPWR net132 sky130_fd_sc_hd__dlygate4sd3_1
X_4129_ _1271_ _1272_ VGND VGND VPWR VPWR _1273_ sky130_fd_sc_hd__or2b_1
XFILLER_0_38_216 VPWR VGND VPWR VGND sky130_ef_sc_hd__decap_12
XFILLER_0_38_249 VGND VGND VPWR VPWR sky130_fd_sc_hd__decap_3
XFILLER_0_53_208 VGND VGND VPWR VPWR sky130_fd_sc_hd__decap_8
XFILLER_0_46_282 VGND VGND VPWR VPWR sky130_fd_sc_hd__fill_1
XFILLER_0_6_390 VGND VGND VPWR VPWR sky130_fd_sc_hd__fill_2
XFILLER_0_16_25 VGND VGND VPWR VPWR sky130_fd_sc_hd__decap_3
XFILLER_0_16_58 VGND VGND VPWR VPWR sky130_fd_sc_hd__fill_2
X_3500_ _1867_ _1942_ _0085_ _2035_ VGND VGND VPWR VPWR _0611_ sky130_fd_sc_hd__nand4_2
XFILLER_0_52_230 VPWR VGND VPWR VGND sky130_ef_sc_hd__decap_12
X_3431_ _0540_ _0541_ _0542_ VGND VGND VPWR VPWR _0543_ sky130_fd_sc_hd__nand3_1
X_3362_ _0472_ _0474_ VGND VGND VPWR VPWR _0475_ sky130_fd_sc_hd__nor2_1
XFILLER_0_20_193 VGND VGND VPWR VPWR sky130_fd_sc_hd__decap_3
X_2313_ net68 _1502_ _1504_ add_tmp\[6\] _1528_ VGND VGND VPWR VPWR _0008_ sky130_fd_sc_hd__a221o_1
X_3293_ net137 _0263_ _0405_ VGND VGND VPWR VPWR _0407_ sky130_fd_sc_hd__or3_1
X_2244_ net56 add_tmp\[28\] VGND VGND VPWR VPWR _1468_ sky130_fd_sc_hd__or2_1
X_2175_ net37 add_tmp\[10\] VGND VGND VPWR VPWR _1340_ sky130_fd_sc_hd__and2_1
XFILLER_0_7_121 VGND VGND VPWR VPWR sky130_fd_sc_hd__decap_8
X_3629_ _0736_ _0738_ VGND VGND VPWR VPWR _0739_ sky130_fd_sc_hd__xnor2_1
XFILLER_0_3_371 VGND VGND VPWR VPWR sky130_fd_sc_hd__fill_1
Xoutput49 net49 VGND VGND VPWR VPWR out_acc[21] sky130_fd_sc_hd__clkbuf_4
Xoutput38 net38 VGND VGND VPWR VPWR out_acc[11] sky130_fd_sc_hd__clkbuf_4
XFILLER_0_3_393 VPWR VGND VPWR VGND sky130_ef_sc_hd__decap_12
XPHY_100 VGND VGND VPWR VPWR sky130_fd_sc_hd__decap_3
XFILLER_0_66_300 VGND VGND VPWR VPWR sky130_fd_sc_hd__decap_4
XPHY_111 VGND VGND VPWR VPWR sky130_fd_sc_hd__decap_3
XPHY_122 VGND VGND VPWR VPWR sky130_fd_sc_hd__decap_3
XFILLER_0_66_344 VGND VGND VPWR VPWR sky130_fd_sc_hd__decap_8
XPHY_133 VGND VGND VPWR VPWR sky130_fd_sc_hd__decap_3
XPHY_155 VGND VGND VPWR VPWR sky130_fd_sc_hd__decap_3
XPHY_144 VGND VGND VPWR VPWR sky130_fd_sc_hd__decap_3
XFILLER_0_19_271 VGND VGND VPWR VPWR sky130_fd_sc_hd__fill_1
XFILLER_0_22_447 VPWR VGND VPWR VGND sky130_ef_sc_hd__decap_12
XFILLER_0_27_57 VGND VGND VPWR VPWR sky130_fd_sc_hd__fill_1
X_3980_ _1043_ _1045_ _1110_ VGND VGND VPWR VPWR _1112_ sky130_fd_sc_hd__or3b_1
XPHY_2 VGND VGND VPWR VPWR sky130_fd_sc_hd__decap_3
XFILLER_0_43_89 VGND VGND VPWR VPWR sky130_fd_sc_hd__decap_8
X_2931_ _2103_ _2104_ _2105_ VGND VGND VPWR VPWR _2106_ sky130_fd_sc_hd__nand3_1
XFILLER_0_69_193 VGND VGND VPWR VPWR sky130_fd_sc_hd__fill_1
XFILLER_0_17_219 VGND VGND VPWR VPWR sky130_fd_sc_hd__decap_4
Xclkbuf_0_clk clk VGND VGND VPWR VPWR clknet_0_clk sky130_fd_sc_hd__clkbuf_16
X_2862_ _1669_ _1975_ _2037_ _1662_ VGND VGND VPWR VPWR _2038_ sky130_fd_sc_hd__a22oi_1
X_2793_ _1967_ net89 _1889_ _1909_ VGND VGND VPWR VPWR _1970_ sky130_fd_sc_hd__a211o_1
XFILLER_0_40_244 VGND VGND VPWR VPWR sky130_fd_sc_hd__decap_3
X_3414_ _0524_ _0525_ VGND VGND VPWR VPWR _0526_ sky130_fd_sc_hd__nor2_1
XFILLER_0_0_352 VGND VGND VPWR VPWR sky130_fd_sc_hd__fill_1
XFILLER_0_0_363 VGND VGND VPWR VPWR sky130_fd_sc_hd__fill_1
XTAP_620 VGND VPWR sky130_fd_sc_hd__tapvpwrvgnd_1
XTAP_631 VGND VPWR sky130_fd_sc_hd__tapvpwrvgnd_1
XTAP_642 VGND VPWR sky130_fd_sc_hd__tapvpwrvgnd_1
XFILLER_0_68_97 VPWR VGND VPWR VGND sky130_ef_sc_hd__decap_12
X_3345_ _0455_ _0456_ _0350_ _0421_ VGND VGND VPWR VPWR _0458_ sky130_fd_sc_hd__o211ai_2
XTAP_653 VGND VPWR sky130_fd_sc_hd__tapvpwrvgnd_1
XTAP_664 VGND VPWR sky130_fd_sc_hd__tapvpwrvgnd_1
XTAP_675 VGND VPWR sky130_fd_sc_hd__tapvpwrvgnd_1
XTAP_686 VGND VPWR sky130_fd_sc_hd__tapvpwrvgnd_1
X_3276_ _0247_ _0256_ VGND VGND VPWR VPWR _0390_ sky130_fd_sc_hd__or2b_1
X_2227_ _1449_ _1450_ VGND VGND VPWR VPWR _1451_ sky130_fd_sc_hd__nand2_1
XTAP_697 VGND VPWR sky130_fd_sc_hd__tapvpwrvgnd_1
X_2158_ net58 add_tmp\[2\] VGND VGND VPWR VPWR _1157_ sky130_fd_sc_hd__nand2_1
XFILLER_0_63_347 VPWR VGND VPWR VGND sky130_ef_sc_hd__decap_12
XFILLER_0_31_244 VGND VGND VPWR VPWR sky130_fd_sc_hd__fill_1
XFILLER_0_39_322 VGND VGND VPWR VPWR sky130_fd_sc_hd__decap_4
XFILLER_0_13_37 VPWR VGND VPWR VGND sky130_ef_sc_hd__decap_12
XFILLER_0_66_141 VPWR VGND VPWR VGND sky130_ef_sc_hd__decap_12
XFILLER_0_66_174 VGND VGND VPWR VPWR sky130_fd_sc_hd__decap_6
XFILLER_0_10_417 VGND VGND VPWR VPWR sky130_fd_sc_hd__decap_3
XFILLER_0_1_127 VPWR VGND VPWR VGND sky130_ef_sc_hd__decap_12
XFILLER_0_22_277 VPWR VGND VPWR VGND sky130_ef_sc_hd__decap_12
X_3130_ net24 VGND VGND VPWR VPWR _0245_ sky130_fd_sc_hd__buf_2
XFILLER_0_38_89 VGND VGND VPWR VPWR sky130_fd_sc_hd__fill_1
X_3061_ _0090_ _0091_ _0176_ VGND VGND VPWR VPWR _0177_ sky130_fd_sc_hd__a21oi_2
XFILLER_0_54_77 VGND VGND VPWR VPWR sky130_fd_sc_hd__fill_2
X_3963_ _1058_ _1030_ _1093_ VGND VGND VPWR VPWR _1094_ sky130_fd_sc_hd__and3_1
X_3894_ _1017_ _1018_ VGND VGND VPWR VPWR _1019_ sky130_fd_sc_hd__nor2_1
X_2914_ _2087_ _2088_ VGND VGND VPWR VPWR _2089_ sky130_fd_sc_hd__and2b_1
X_2845_ _1935_ _1943_ _1941_ VGND VGND VPWR VPWR _2021_ sky130_fd_sc_hd__a21bo_1
XFILLER_0_13_211 VPWR VGND VPWR VGND sky130_ef_sc_hd__decap_12
X_2776_ _1949_ _1950_ _1951_ VGND VGND VPWR VPWR _1953_ sky130_fd_sc_hd__a21o_1
XFILLER_0_53_391 VGND VGND VPWR VPWR sky130_fd_sc_hd__fill_1
XTAP_450 VGND VPWR sky130_fd_sc_hd__tapvpwrvgnd_1
X_3328_ _0438_ _0439_ _0440_ VGND VGND VPWR VPWR _0441_ sky130_fd_sc_hd__nand3_1
XTAP_461 VGND VPWR sky130_fd_sc_hd__tapvpwrvgnd_1
XTAP_472 VGND VPWR sky130_fd_sc_hd__tapvpwrvgnd_1
XTAP_483 VGND VPWR sky130_fd_sc_hd__tapvpwrvgnd_1
XTAP_494 VGND VPWR sky130_fd_sc_hd__tapvpwrvgnd_1
X_3259_ _0368_ _0370_ _0372_ VGND VGND VPWR VPWR _0373_ sky130_fd_sc_hd__a21o_1
XFILLER_0_63_133 VGND VGND VPWR VPWR sky130_fd_sc_hd__decap_6
XFILLER_0_51_306 VGND VGND VPWR VPWR sky130_fd_sc_hd__decap_8
XFILLER_0_67_461 VGND VGND VPWR VPWR sky130_fd_sc_hd__fill_2
X_2630_ _1738_ _1768_ _1809_ _1807_ VGND VGND VPWR VPWR _1810_ sky130_fd_sc_hd__o22a_1
XFILLER_0_40_68 VPWR VGND VPWR VGND sky130_ef_sc_hd__decap_12
X_2561_ _1691_ _1740_ _1741_ _1742_ VGND VGND VPWR VPWR _0042_ sky130_fd_sc_hd__a31o_1
XFILLER_0_49_11 VGND VGND VPWR VPWR sky130_fd_sc_hd__fill_2
X_2492_ _1675_ _1676_ VGND VGND VPWR VPWR _1677_ sky130_fd_sc_hd__nor2_1
X_4300_ clknet_3_6__leaf_clk _0045_ net35 VGND VGND VPWR VPWR add_tmp\[7\] sky130_fd_sc_hd__dfrtp_1
X_4231_ _1380_ _1381_ VGND VGND VPWR VPWR _1382_ sky130_fd_sc_hd__xnor2_1
X_4162_ _0867_ _1257_ _1239_ _1240_ _1238_ VGND VGND VPWR VPWR _1309_ sky130_fd_sc_hd__o221ai_1
X_4093_ _1192_ _1197_ VGND VGND VPWR VPWR _1234_ sky130_fd_sc_hd__or2b_1
X_3113_ net76 net84 _0226_ _0228_ VGND VGND VPWR VPWR _0229_ sky130_fd_sc_hd__o211ai_4
X_3044_ _0159_ VGND VGND VPWR VPWR _0160_ sky130_fd_sc_hd__clkbuf_2
XFILLER_0_77_225 VGND VGND VPWR VPWR sky130_fd_sc_hd__decap_8
XFILLER_0_18_303 VGND VGND VPWR VPWR sky130_fd_sc_hd__fill_1
X_3946_ _1072_ _1073_ _1074_ VGND VGND VPWR VPWR _1075_ sky130_fd_sc_hd__nand3_1
X_3877_ _0997_ _0998_ _0999_ VGND VGND VPWR VPWR _1000_ sky130_fd_sc_hd__a21o_1
X_2828_ _1998_ _2003_ VGND VGND VPWR VPWR _2004_ sky130_fd_sc_hd__xor2_2
XFILLER_0_60_147 VGND VGND VPWR VPWR sky130_fd_sc_hd__fill_1
X_2759_ _1723_ VGND VGND VPWR VPWR _1936_ sky130_fd_sc_hd__buf_6
XTAP_291 VGND VPWR sky130_fd_sc_hd__tapvpwrvgnd_1
XTAP_280 VGND VPWR sky130_fd_sc_hd__tapvpwrvgnd_1
XFILLER_0_24_306 VGND VGND VPWR VPWR sky130_fd_sc_hd__fill_2
XFILLER_0_51_158 VGND VGND VPWR VPWR sky130_fd_sc_hd__decap_8
XFILLER_0_35_57 VGND VGND VPWR VPWR sky130_fd_sc_hd__decap_6
X_3800_ _0431_ _0376_ _0914_ _0915_ VGND VGND VPWR VPWR _0916_ sky130_fd_sc_hd__nand4_4
XFILLER_0_27_111 VGND VGND VPWR VPWR sky130_fd_sc_hd__fill_1
X_3731_ _0757_ _0569_ _0473_ _0191_ VGND VGND VPWR VPWR _0841_ sky130_fd_sc_hd__a22oi_1
XFILLER_0_15_317 VGND VGND VPWR VPWR sky130_fd_sc_hd__decap_8
X_3662_ _0769_ _0763_ _0764_ VGND VGND VPWR VPWR _0771_ sky130_fd_sc_hd__nand3_1
X_2613_ _1790_ _1791_ _1792_ VGND VGND VPWR VPWR _1793_ sky130_fd_sc_hd__and3_1
X_3593_ _0698_ _0701_ _0702_ VGND VGND VPWR VPWR _0703_ sky130_fd_sc_hd__nand3_1
XFILLER_0_42_147 VGND VGND VPWR VPWR sky130_fd_sc_hd__fill_1
XFILLER_0_23_372 VPWR VGND VPWR VGND sky130_ef_sc_hd__decap_12
X_2544_ net26 VGND VGND VPWR VPWR _1726_ sky130_fd_sc_hd__buf_4
X_2475_ _1660_ VGND VGND VPWR VPWR _1661_ sky130_fd_sc_hd__dlymetal6s2s_1
XFILLER_0_76_53 VPWR VGND VPWR VGND sky130_ef_sc_hd__decap_12
X_4214_ _1363_ _1364_ VGND VGND VPWR VPWR _1365_ sky130_fd_sc_hd__or2b_1
XFILLER_0_76_97 VPWR VGND VPWR VGND sky130_ef_sc_hd__decap_12
X_4145_ _0519_ _1289_ VGND VGND VPWR VPWR _1290_ sky130_fd_sc_hd__and2_1
X_4076_ _1208_ _1215_ VGND VGND VPWR VPWR _1216_ sky130_fd_sc_hd__and2_1
X_3027_ _0141_ _0142_ net111 _2118_ VGND VGND VPWR VPWR _0144_ sky130_fd_sc_hd__o211ai_2
XFILLER_0_18_100 VGND VGND VPWR VPWR sky130_fd_sc_hd__decap_4
XFILLER_0_65_217 VGND VGND VPWR VPWR sky130_fd_sc_hd__decap_6
X_3929_ _1033_ _1037_ VGND VGND VPWR VPWR _1056_ sky130_fd_sc_hd__nand2_1
XFILLER_0_56_239 VGND VGND VPWR VPWR sky130_fd_sc_hd__decap_6
XFILLER_0_21_15 VPWR VGND VPWR VGND sky130_ef_sc_hd__decap_12
XFILLER_0_21_37 VPWR VGND VPWR VGND sky130_ef_sc_hd__decap_12
XFILLER_0_52_445 VPWR VGND VPWR VGND sky130_ef_sc_hd__decap_12
X_2260_ en_delay VGND VGND VPWR VPWR _1484_ sky130_fd_sc_hd__inv_2
X_2191_ _1407_ _1414_ VGND VGND VPWR VPWR _1415_ sky130_fd_sc_hd__or2_1
XFILLER_0_46_89 VPWR VGND VPWR VGND sky130_ef_sc_hd__decap_12
XFILLER_0_1_36 VPWR VGND VPWR VGND sky130_ef_sc_hd__decap_12
XFILLER_0_47_239 VGND VGND VPWR VPWR sky130_fd_sc_hd__decap_4
XFILLER_0_62_209 VPWR VGND VPWR VGND sky130_ef_sc_hd__decap_12
X_3714_ _0818_ _0823_ VGND VGND VPWR VPWR _0824_ sky130_fd_sc_hd__or2_1
X_3645_ _0682_ VGND VGND VPWR VPWR _0754_ sky130_fd_sc_hd__inv_2
X_3576_ _0683_ _0684_ _0680_ _0612_ VGND VGND VPWR VPWR _0686_ sky130_fd_sc_hd__a211o_1
X_2527_ _1690_ _1709_ VGND VGND VPWR VPWR _1710_ sky130_fd_sc_hd__nor2_1
X_2458_ _1646_ VGND VGND VPWR VPWR _0035_ sky130_fd_sc_hd__clkbuf_1
XFILLER_0_53_3 VGND VGND VPWR VPWR sky130_fd_sc_hd__decap_6
X_2389_ _1585_ VGND VGND VPWR VPWR _1590_ sky130_fd_sc_hd__inv_2
X_4128_ _1231_ _1233_ _1270_ VGND VGND VPWR VPWR _1272_ sky130_fd_sc_hd__nand3_1
X_4059_ _2064_ _1194_ _1196_ VGND VGND VPWR VPWR _1197_ sky130_fd_sc_hd__a21oi_1
XFILLER_0_38_228 VGND VGND VPWR VPWR sky130_fd_sc_hd__decap_4
XFILLER_0_19_442 VGND VGND VPWR VPWR sky130_fd_sc_hd__decap_6
XFILLER_0_61_253 VGND VGND VPWR VPWR sky130_fd_sc_hd__fill_2
XFILLER_0_16_15 VGND VGND VPWR VPWR sky130_fd_sc_hd__decap_3
XFILLER_0_16_37 VGND VGND VPWR VPWR sky130_fd_sc_hd__fill_1
XFILLER_0_29_206 VGND VGND VPWR VPWR sky130_fd_sc_hd__decap_8
XFILLER_0_32_25 VGND VGND VPWR VPWR sky130_fd_sc_hd__decap_3
XFILLER_0_25_445 VGND VGND VPWR VPWR sky130_fd_sc_hd__decap_3
XFILLER_0_52_242 VGND VGND VPWR VPWR sky130_fd_sc_hd__decap_8
XFILLER_0_40_415 VGND VGND VPWR VPWR sky130_fd_sc_hd__fill_1
XFILLER_0_40_437 VGND VGND VPWR VPWR sky130_fd_sc_hd__fill_2
X_3430_ _0437_ _0429_ _0428_ VGND VGND VPWR VPWR _0542_ sky130_fd_sc_hd__a21bo_1
X_3361_ _1955_ _0203_ _0078_ _0473_ VGND VGND VPWR VPWR _0474_ sky130_fd_sc_hd__and4_1
X_2312_ _1232_ _1526_ _1527_ VGND VGND VPWR VPWR _1528_ sky130_fd_sc_hd__o21a_1
XFILLER_0_57_11 VGND VGND VPWR VPWR sky130_fd_sc_hd__fill_1
X_3292_ net142 _0263_ _0405_ VGND VGND VPWR VPWR _0406_ sky130_fd_sc_hd__o21ai_2
X_2243_ net56 add_tmp\[28\] VGND VGND VPWR VPWR _1467_ sky130_fd_sc_hd__nand2_1
X_2174_ net38 add_tmp\[11\] VGND VGND VPWR VPWR _1330_ sky130_fd_sc_hd__and2_1
XFILLER_0_75_389 VGND VGND VPWR VPWR sky130_fd_sc_hd__decap_3
XFILLER_0_7_111 VGND VGND VPWR VPWR sky130_fd_sc_hd__fill_1
XFILLER_0_7_133 VGND VGND VPWR VPWR sky130_fd_sc_hd__decap_8
XFILLER_0_22_80 VGND VGND VPWR VPWR sky130_fd_sc_hd__decap_4
XFILLER_0_22_91 VGND VGND VPWR VPWR sky130_fd_sc_hd__decap_6
XFILLER_0_31_426 VPWR VGND VPWR VGND sky130_ef_sc_hd__decap_12
X_3628_ _0663_ _0665_ _0737_ VGND VGND VPWR VPWR _0738_ sky130_fd_sc_hd__o21ba_1
Xoutput39 net39 VGND VGND VPWR VPWR out_acc[12] sky130_fd_sc_hd__clkbuf_4
X_3559_ _0598_ _0660_ VGND VGND VPWR VPWR _0669_ sky130_fd_sc_hd__nand2_1
XPHY_101 VGND VGND VPWR VPWR sky130_fd_sc_hd__decap_3
XPHY_112 VGND VGND VPWR VPWR sky130_fd_sc_hd__decap_3
XPHY_123 VGND VGND VPWR VPWR sky130_fd_sc_hd__decap_3
XPHY_134 VGND VGND VPWR VPWR sky130_fd_sc_hd__decap_3
XPHY_145 VGND VGND VPWR VPWR sky130_fd_sc_hd__decap_3
XFILLER_0_22_459 VGND VGND VPWR VPWR sky130_fd_sc_hd__decap_4
XFILLER_0_76_109 VPWR VGND VPWR VGND sky130_ef_sc_hd__decap_12
XPHY_3 VGND VGND VPWR VPWR sky130_fd_sc_hd__decap_3
XFILLER_0_43_57 VPWR VGND VPWR VGND sky130_ef_sc_hd__decap_12
X_2930_ _2014_ _2023_ _2022_ VGND VGND VPWR VPWR _2105_ sky130_fd_sc_hd__a21bo_1
X_2861_ _2036_ VGND VGND VPWR VPWR _2037_ sky130_fd_sc_hd__clkbuf_2
X_2792_ _1889_ _1909_ _1967_ net89 VGND VGND VPWR VPWR _1969_ sky130_fd_sc_hd__o211ai_2
XFILLER_0_7_57 VPWR VGND VPWR VGND sky130_ef_sc_hd__decap_12
X_3413_ _0481_ _0484_ _0523_ VGND VGND VPWR VPWR _0525_ sky130_fd_sc_hd__o21a_1
XFILLER_0_68_54 VGND VGND VPWR VPWR sky130_fd_sc_hd__fill_1
XTAP_610 VGND VPWR sky130_fd_sc_hd__tapvpwrvgnd_1
XTAP_621 VGND VPWR sky130_fd_sc_hd__tapvpwrvgnd_1
XTAP_632 VGND VPWR sky130_fd_sc_hd__tapvpwrvgnd_1
XTAP_643 VGND VPWR sky130_fd_sc_hd__tapvpwrvgnd_1
X_3344_ _0350_ _0421_ _0455_ _0456_ VGND VGND VPWR VPWR _0457_ sky130_fd_sc_hd__a211o_1
XTAP_654 VGND VPWR sky130_fd_sc_hd__tapvpwrvgnd_1
XTAP_665 VGND VPWR sky130_fd_sc_hd__tapvpwrvgnd_1
XTAP_676 VGND VPWR sky130_fd_sc_hd__tapvpwrvgnd_1
X_3275_ _0254_ _0255_ VGND VGND VPWR VPWR _0389_ sky130_fd_sc_hd__nand2_1
X_2226_ net52 add_tmp\[24\] VGND VGND VPWR VPWR _1450_ sky130_fd_sc_hd__or2_1
XTAP_687 VGND VPWR sky130_fd_sc_hd__tapvpwrvgnd_1
XTAP_698 VGND VPWR sky130_fd_sc_hd__tapvpwrvgnd_1
XFILLER_0_17_91 VGND VGND VPWR VPWR sky130_fd_sc_hd__decap_8
XFILLER_0_16_3 VPWR VGND VPWR VGND sky130_ef_sc_hd__decap_12
X_2157_ _1114_ _1124_ _1135_ VGND VGND VPWR VPWR _1146_ sky130_fd_sc_hd__a21boi_2
XFILLER_0_63_337 VGND VGND VPWR VPWR sky130_fd_sc_hd__decap_6
XFILLER_0_16_231 VPWR VGND VPWR VGND sky130_ef_sc_hd__decap_12
XFILLER_0_63_359 VPWR VGND VPWR VGND sky130_ef_sc_hd__decap_12
XFILLER_0_16_253 VPWR VGND VPWR VGND sky130_ef_sc_hd__decap_12
XFILLER_0_16_286 VPWR VGND VPWR VGND sky130_ef_sc_hd__decap_12
XFILLER_0_31_212 VGND VGND VPWR VPWR sky130_fd_sc_hd__fill_2
XFILLER_0_71_381 VGND VGND VPWR VPWR sky130_fd_sc_hd__fill_1
XFILLER_0_66_153 VGND VGND VPWR VPWR sky130_fd_sc_hd__fill_1
XFILLER_0_13_49 VGND VGND VPWR VPWR sky130_fd_sc_hd__decap_6
XFILLER_0_22_201 VGND VGND VPWR VPWR sky130_fd_sc_hd__fill_1
XFILLER_0_22_289 VPWR VGND VPWR VGND sky130_ef_sc_hd__decap_12
X_3060_ _1663_ _0080_ _0092_ VGND VGND VPWR VPWR _0176_ sky130_fd_sc_hd__and3_1
XFILLER_0_77_429 VPWR VGND VPWR VGND sky130_ef_sc_hd__decap_12
X_3962_ _1090_ _1091_ VGND VGND VPWR VPWR _1093_ sky130_fd_sc_hd__or2_1
X_3893_ _0633_ _0340_ _0078_ _0158_ VGND VGND VPWR VPWR _1018_ sky130_fd_sc_hd__and4_1
XFILLER_0_45_315 VGND VGND VPWR VPWR sky130_fd_sc_hd__fill_2
XFILLER_0_45_337 VPWR VGND VPWR VGND sky130_ef_sc_hd__decap_12
X_2913_ _2010_ _1870_ _1830_ _1783_ VGND VGND VPWR VPWR _2088_ sky130_fd_sc_hd__a22o_1
XFILLER_0_45_359 VGND VGND VPWR VPWR sky130_fd_sc_hd__decap_6
X_2844_ _2017_ _2018_ _2015_ VGND VGND VPWR VPWR _2020_ sky130_fd_sc_hd__a21o_1
XFILLER_0_13_223 VGND VGND VPWR VPWR sky130_fd_sc_hd__fill_1
X_2775_ _1949_ _1950_ _1951_ VGND VGND VPWR VPWR _1952_ sky130_fd_sc_hd__nand3_2
XFILLER_0_0_161 VGND VGND VPWR VPWR sky130_fd_sc_hd__decap_6
XTAP_440 VGND VPWR sky130_fd_sc_hd__tapvpwrvgnd_1
XTAP_451 VGND VPWR sky130_fd_sc_hd__tapvpwrvgnd_1
X_3327_ _0346_ _0339_ _0338_ VGND VGND VPWR VPWR _0440_ sky130_fd_sc_hd__a21bo_1
XTAP_462 VGND VPWR sky130_fd_sc_hd__tapvpwrvgnd_1
XTAP_473 VGND VPWR sky130_fd_sc_hd__tapvpwrvgnd_1
XTAP_484 VGND VPWR sky130_fd_sc_hd__tapvpwrvgnd_1
XTAP_495 VGND VPWR sky130_fd_sc_hd__tapvpwrvgnd_1
X_3258_ _2007_ _0371_ VGND VGND VPWR VPWR _0372_ sky130_fd_sc_hd__and2_1
X_2209_ _1416_ _1419_ _1429_ _1432_ VGND VGND VPWR VPWR _1433_ sky130_fd_sc_hd__a211o_2
X_3189_ _0301_ _0302_ _0201_ _0264_ VGND VGND VPWR VPWR _0304_ sky130_fd_sc_hd__o211ai_1
XFILLER_0_68_418 VGND VGND VPWR VPWR sky130_fd_sc_hd__fill_2
XFILLER_0_48_175 VGND VGND VPWR VPWR sky130_fd_sc_hd__fill_1
XFILLER_0_36_337 VGND VGND VPWR VPWR sky130_fd_sc_hd__decap_3
XFILLER_0_48_197 VGND VGND VPWR VPWR sky130_fd_sc_hd__decap_4
XFILLER_0_51_329 VGND VGND VPWR VPWR sky130_fd_sc_hd__fill_1
XFILLER_0_63_167 VGND VGND VPWR VPWR sky130_fd_sc_hd__fill_1
XFILLER_0_44_381 VGND VGND VPWR VPWR sky130_fd_sc_hd__decap_3
XFILLER_0_39_131 VGND VGND VPWR VPWR sky130_fd_sc_hd__fill_2
XFILLER_0_27_326 VGND VGND VPWR VPWR sky130_fd_sc_hd__fill_1
XFILLER_0_39_175 VGND VGND VPWR VPWR sky130_fd_sc_hd__fill_1
XFILLER_0_40_47 VGND VGND VPWR VPWR sky130_fd_sc_hd__fill_1
XFILLER_0_42_329 VGND VGND VPWR VPWR sky130_fd_sc_hd__fill_1
XFILLER_0_54_167 VGND VGND VPWR VPWR sky130_fd_sc_hd__fill_1
XFILLER_0_35_370 VGND VGND VPWR VPWR sky130_fd_sc_hd__decap_8
XFILLER_0_54_189 VGND VGND VPWR VPWR sky130_fd_sc_hd__fill_2
X_2560_ add_tmp\[4\] _1655_ VGND VGND VPWR VPWR _1742_ sky130_fd_sc_hd__and2_1
X_2491_ _1659_ _1670_ _1673_ _1663_ VGND VGND VPWR VPWR _1676_ sky130_fd_sc_hd__and4_1
X_4230_ _1342_ _1350_ _1343_ VGND VGND VPWR VPWR _1381_ sky130_fd_sc_hd__o21a_1
XFILLER_0_49_78 VGND VGND VPWR VPWR sky130_fd_sc_hd__decap_4
X_4161_ _0867_ _1257_ _1238_ VGND VGND VPWR VPWR _1307_ sky130_fd_sc_hd__or3_2
XFILLER_0_4_58 VGND VGND VPWR VPWR sky130_fd_sc_hd__decap_4
XFILLER_0_65_11 VGND VGND VPWR VPWR sky130_fd_sc_hd__decap_3
X_4092_ _1221_ _1224_ VGND VGND VPWR VPWR _1233_ sky130_fd_sc_hd__or2b_1
X_3112_ _0225_ _0227_ _0223_ VGND VGND VPWR VPWR _0228_ sky130_fd_sc_hd__or3b_4
X_3043_ _0158_ VGND VGND VPWR VPWR _0159_ sky130_fd_sc_hd__clkbuf_2
XFILLER_0_14_81 VGND VGND VPWR VPWR sky130_fd_sc_hd__decap_3
X_3945_ _1009_ _1011_ _1010_ VGND VGND VPWR VPWR _1074_ sky130_fd_sc_hd__a21bo_1
X_3876_ _0934_ _0942_ VGND VGND VPWR VPWR _0999_ sky130_fd_sc_hd__nand2_1
XFILLER_0_33_307 VGND VGND VPWR VPWR sky130_fd_sc_hd__decap_8
XFILLER_0_45_167 VGND VGND VPWR VPWR sky130_fd_sc_hd__fill_1
X_2827_ _2001_ _2002_ VGND VGND VPWR VPWR _2003_ sky130_fd_sc_hd__or2_4
XFILLER_0_60_137 VGND VGND VPWR VPWR sky130_fd_sc_hd__decap_3
X_2758_ _1934_ _1830_ VGND VGND VPWR VPWR _1935_ sky130_fd_sc_hd__and2_4
X_2689_ net17 VGND VGND VPWR VPWR _1867_ sky130_fd_sc_hd__buf_4
XTAP_292 VGND VPWR sky130_fd_sc_hd__tapvpwrvgnd_1
XTAP_281 VGND VPWR sky130_fd_sc_hd__tapvpwrvgnd_1
XTAP_270 VGND VPWR sky130_fd_sc_hd__tapvpwrvgnd_1
XFILLER_0_36_156 VGND VGND VPWR VPWR sky130_fd_sc_hd__decap_6
XFILLER_0_51_126 VGND VGND VPWR VPWR sky130_fd_sc_hd__fill_2
XFILLER_0_19_37 VGND VGND VPWR VPWR sky130_fd_sc_hd__fill_1
XFILLER_0_59_248 VGND VGND VPWR VPWR sky130_fd_sc_hd__fill_1
X_3730_ _0836_ _0838_ _0759_ _0760_ VGND VGND VPWR VPWR _0840_ sky130_fd_sc_hd__o211ai_1
XFILLER_0_67_281 VGND VGND VPWR VPWR sky130_fd_sc_hd__decap_8
X_3661_ _0763_ _0764_ _0769_ VGND VGND VPWR VPWR _0770_ sky130_fd_sc_hd__a21o_1
XFILLER_0_2_201 VGND VGND VPWR VPWR sky130_fd_sc_hd__fill_1
X_2612_ _1761_ _1751_ _1750_ VGND VGND VPWR VPWR _1792_ sky130_fd_sc_hd__a21bo_1
X_3592_ _1895_ _0430_ _0699_ _0700_ VGND VGND VPWR VPWR _0702_ sky130_fd_sc_hd__a22o_1
XFILLER_0_23_384 VGND VGND VPWR VPWR sky130_fd_sc_hd__decap_8
X_2543_ net19 VGND VGND VPWR VPWR _1725_ sky130_fd_sc_hd__buf_6
X_2474_ net3 VGND VGND VPWR VPWR _1660_ sky130_fd_sc_hd__buf_1
XFILLER_0_76_65 VPWR VGND VPWR VGND sky130_ef_sc_hd__decap_12
X_4213_ _1320_ _1328_ _1359_ _1361_ VGND VGND VPWR VPWR _1364_ sky130_fd_sc_hd__a22o_1
X_4144_ _1287_ _1288_ VGND VGND VPWR VPWR _1289_ sky130_fd_sc_hd__nor2_1
X_4075_ _1210_ _1214_ VGND VGND VPWR VPWR _1215_ sky130_fd_sc_hd__xor2_1
X_3026_ net111 _2118_ _0141_ _0142_ VGND VGND VPWR VPWR _0143_ sky130_fd_sc_hd__a211o_1
XFILLER_0_18_134 VGND VGND VPWR VPWR sky130_fd_sc_hd__decap_6
XFILLER_0_46_421 VPWR VGND VPWR VGND sky130_ef_sc_hd__decap_12
X_3928_ _1055_ VGND VGND VPWR VPWR _0061_ sky130_fd_sc_hd__clkbuf_1
XFILLER_0_18_178 VPWR VGND VPWR VGND sky130_ef_sc_hd__decap_12
X_3859_ _0978_ _0980_ VGND VGND VPWR VPWR _0981_ sky130_fd_sc_hd__xnor2_2
XFILLER_0_49_281 VPWR VGND VPWR VGND sky130_ef_sc_hd__decap_12
XFILLER_0_21_27 VGND VGND VPWR VPWR sky130_fd_sc_hd__fill_2
XFILLER_0_64_240 VPWR VGND VPWR VGND sky130_ef_sc_hd__decap_12
XFILLER_0_21_49 VGND VGND VPWR VPWR sky130_fd_sc_hd__fill_1
XFILLER_0_64_273 VGND VGND VPWR VPWR sky130_fd_sc_hd__decap_4
XFILLER_0_52_457 VGND VGND VPWR VPWR sky130_fd_sc_hd__decap_6
XFILLER_0_20_365 VGND VGND VPWR VPWR sky130_fd_sc_hd__decap_3
XFILLER_0_46_24 VGND VGND VPWR VPWR sky130_fd_sc_hd__decap_4
X_2190_ _1410_ _1413_ VGND VGND VPWR VPWR _1414_ sky130_fd_sc_hd__or2_1
XFILLER_0_1_48 VGND VGND VPWR VPWR sky130_fd_sc_hd__decap_8
XFILLER_0_28_421 VGND VGND VPWR VPWR sky130_fd_sc_hd__decap_3
XFILLER_0_7_337 VPWR VGND VPWR VGND sky130_ef_sc_hd__decap_12
X_3713_ _0507_ _0512_ _0593_ _0819_ _0822_ VGND VGND VPWR VPWR _0823_ sky130_fd_sc_hd__o41a_1
X_3644_ _0705_ _0704_ _0703_ VGND VGND VPWR VPWR _0753_ sky130_fd_sc_hd__a21bo_1
X_3575_ _0680_ _0612_ _0683_ _0684_ VGND VGND VPWR VPWR _0685_ sky130_fd_sc_hd__o211ai_2
X_2526_ _1705_ _1708_ VGND VGND VPWR VPWR _1709_ sky130_fd_sc_hd__xor2_1
X_2457_ net62 _1645_ _1636_ VGND VGND VPWR VPWR _1646_ sky130_fd_sc_hd__mux2_1
XFILLER_0_46_3 VGND VGND VPWR VPWR sky130_fd_sc_hd__decap_8
X_2388_ _1589_ VGND VGND VPWR VPWR _0022_ sky130_fd_sc_hd__clkbuf_1
X_4127_ _1231_ _1233_ _1270_ VGND VGND VPWR VPWR _1271_ sky130_fd_sc_hd__a21oi_1
X_4058_ _2064_ _1195_ _1193_ VGND VGND VPWR VPWR _1196_ sky130_fd_sc_hd__a21oi_1
X_3009_ _0122_ _0123_ _0124_ VGND VGND VPWR VPWR _0126_ sky130_fd_sc_hd__a21o_1
XFILLER_0_46_262 VGND VGND VPWR VPWR sky130_fd_sc_hd__decap_8
XFILLER_0_61_221 VGND VGND VPWR VPWR sky130_fd_sc_hd__decap_3
XFILLER_0_4_307 VGND VGND VPWR VPWR sky130_fd_sc_hd__fill_1
X_3360_ _0470_ VGND VGND VPWR VPWR _0473_ sky130_fd_sc_hd__clkbuf_2
X_2311_ _1232_ _1526_ _1499_ VGND VGND VPWR VPWR _1527_ sky130_fd_sc_hd__a21oi_1
XFILLER_0_57_23 VPWR VGND VPWR VGND sky130_ef_sc_hd__decap_12
X_3291_ _0401_ _0404_ VGND VGND VPWR VPWR _0405_ sky130_fd_sc_hd__xnor2_1
X_2242_ _1458_ _1465_ VGND VGND VPWR VPWR _1466_ sky130_fd_sc_hd__or2_1
X_2173_ _1027_ _1297_ _1308_ VGND VGND VPWR VPWR _1319_ sky130_fd_sc_hd__o21ai_2
XFILLER_0_73_55 VGND VGND VPWR VPWR sky130_fd_sc_hd__fill_1
XFILLER_0_75_357 VGND VGND VPWR VPWR sky130_fd_sc_hd__fill_1
XFILLER_0_7_178 VGND VGND VPWR VPWR sky130_fd_sc_hd__fill_2
XFILLER_0_43_221 VGND VGND VPWR VPWR sky130_fd_sc_hd__decap_3
X_3627_ _0662_ _0661_ VGND VGND VPWR VPWR _0737_ sky130_fd_sc_hd__and2b_1
XFILLER_0_31_438 VGND VGND VPWR VPWR sky130_fd_sc_hd__decap_8
XFILLER_0_31_449 VGND VGND VPWR VPWR sky130_fd_sc_hd__decap_8
XFILLER_0_43_298 VGND VGND VPWR VPWR sky130_fd_sc_hd__fill_2
XFILLER_0_11_140 VPWR VGND VPWR VGND sky130_ef_sc_hd__decap_12
X_3558_ _0659_ _0658_ VGND VGND VPWR VPWR _0668_ sky130_fd_sc_hd__or2b_1
X_2509_ add_tmp\[2\] _1656_ _1690_ _1692_ VGND VGND VPWR VPWR _0040_ sky130_fd_sc_hd__a22o_1
X_3489_ _0375_ _0517_ _0571_ VGND VGND VPWR VPWR _0600_ sky130_fd_sc_hd__and3b_2
XPHY_102 VGND VGND VPWR VPWR sky130_fd_sc_hd__decap_3
XPHY_113 VGND VGND VPWR VPWR sky130_fd_sc_hd__decap_3
XPHY_124 VGND VGND VPWR VPWR sky130_fd_sc_hd__decap_3
XPHY_135 VGND VGND VPWR VPWR sky130_fd_sc_hd__decap_3
XPHY_146 VGND VGND VPWR VPWR sky130_fd_sc_hd__decap_3
XFILLER_0_34_232 VGND VGND VPWR VPWR sky130_fd_sc_hd__decap_4
XFILLER_0_22_427 VGND VGND VPWR VPWR sky130_fd_sc_hd__fill_1
XFILLER_0_30_460 VGND VGND VPWR VPWR sky130_fd_sc_hd__decap_3
XPHY_4 VGND VGND VPWR VPWR sky130_fd_sc_hd__decap_3
XFILLER_0_43_69 VGND VGND VPWR VPWR sky130_fd_sc_hd__decap_4
XFILLER_0_57_335 VGND VGND VPWR VPWR sky130_fd_sc_hd__fill_1
X_2860_ _2035_ VGND VGND VPWR VPWR _2036_ sky130_fd_sc_hd__clkbuf_2
XFILLER_0_25_210 VPWR VGND VPWR VGND sky130_ef_sc_hd__decap_12
XFILLER_0_25_232 VGND VGND VPWR VPWR sky130_fd_sc_hd__decap_4
XFILLER_0_25_243 VGND VGND VPWR VPWR sky130_fd_sc_hd__decap_8
X_2791_ _1966_ _1952_ _1953_ VGND VGND VPWR VPWR _1968_ sky130_fd_sc_hd__nand3_2
XFILLER_0_13_405 VGND VGND VPWR VPWR sky130_fd_sc_hd__fill_2
XFILLER_0_13_449 VPWR VGND VPWR VGND sky130_ef_sc_hd__decap_12
XFILLER_0_7_69 VGND VGND VPWR VPWR sky130_fd_sc_hd__fill_2
XFILLER_0_40_268 VGND VGND VPWR VPWR sky130_fd_sc_hd__fill_2
X_3412_ _0481_ _0484_ _0523_ VGND VGND VPWR VPWR _0524_ sky130_fd_sc_hd__nor3_1
XFILLER_0_0_343 VGND VGND VPWR VPWR sky130_fd_sc_hd__fill_2
XTAP_600 VGND VPWR sky130_fd_sc_hd__tapvpwrvgnd_1
XFILLER_0_68_77 VGND VGND VPWR VPWR sky130_fd_sc_hd__decap_6
XFILLER_0_0_365 VGND VGND VPWR VPWR sky130_fd_sc_hd__decap_8
XFILLER_0_0_387 VGND VGND VPWR VPWR sky130_fd_sc_hd__decap_4
XTAP_611 VGND VPWR sky130_fd_sc_hd__tapvpwrvgnd_1
XTAP_622 VGND VPWR sky130_fd_sc_hd__tapvpwrvgnd_1
XTAP_633 VGND VPWR sky130_fd_sc_hd__tapvpwrvgnd_1
X_3343_ _0454_ _0441_ _0442_ VGND VGND VPWR VPWR _0456_ sky130_fd_sc_hd__and3_1
XTAP_644 VGND VPWR sky130_fd_sc_hd__tapvpwrvgnd_1
XTAP_655 VGND VPWR sky130_fd_sc_hd__tapvpwrvgnd_1
XTAP_666 VGND VPWR sky130_fd_sc_hd__tapvpwrvgnd_1
XTAP_677 VGND VPWR sky130_fd_sc_hd__tapvpwrvgnd_1
X_3274_ _0385_ _0386_ _0367_ VGND VGND VPWR VPWR _0388_ sky130_fd_sc_hd__a21oi_1
X_2225_ net52 add_tmp\[24\] VGND VGND VPWR VPWR _1449_ sky130_fd_sc_hd__nand2_1
XTAP_688 VGND VPWR sky130_fd_sc_hd__tapvpwrvgnd_1
XTAP_699 VGND VPWR sky130_fd_sc_hd__tapvpwrvgnd_1
X_2156_ net47 add_tmp\[1\] VGND VGND VPWR VPWR _1135_ sky130_fd_sc_hd__nand2_1
XFILLER_0_48_335 VGND VGND VPWR VPWR sky130_fd_sc_hd__fill_1
XFILLER_0_8_421 VPWR VGND VPWR VGND sky130_ef_sc_hd__decap_12
XFILLER_0_48_346 VPWR VGND VPWR VGND sky130_ef_sc_hd__decap_12
XFILLER_0_63_316 VGND VGND VPWR VPWR sky130_fd_sc_hd__decap_3
XFILLER_0_16_221 VGND VGND VPWR VPWR sky130_fd_sc_hd__decap_4
X_2989_ _0097_ net115 VGND VGND VPWR VPWR _0106_ sky130_fd_sc_hd__xnor2_2
XFILLER_0_16_265 VGND VGND VPWR VPWR sky130_fd_sc_hd__decap_4
XFILLER_0_16_243 VGND VGND VPWR VPWR sky130_fd_sc_hd__decap_3
XFILLER_0_31_202 VGND VGND VPWR VPWR sky130_fd_sc_hd__decap_6
XFILLER_0_16_298 VGND VGND VPWR VPWR sky130_fd_sc_hd__decap_8
XFILLER_0_31_279 VGND VGND VPWR VPWR sky130_fd_sc_hd__fill_1
XFILLER_0_39_335 VGND VGND VPWR VPWR sky130_fd_sc_hd__fill_1
XFILLER_0_66_121 VGND VGND VPWR VPWR sky130_fd_sc_hd__decap_3
XFILLER_0_54_327 VGND VGND VPWR VPWR sky130_fd_sc_hd__fill_1
XFILLER_0_77_419 VGND VGND VPWR VPWR sky130_fd_sc_hd__fill_1
X_3961_ _1089_ _1080_ _1082_ VGND VGND VPWR VPWR _1091_ sky130_fd_sc_hd__and3_1
XFILLER_0_9_218 VGND VGND VPWR VPWR sky130_fd_sc_hd__fill_1
X_2912_ _1782_ _1755_ _1870_ _1827_ VGND VGND VPWR VPWR _2087_ sky130_fd_sc_hd__and4_1
X_3892_ _0431_ _0569_ _0471_ _0629_ VGND VGND VPWR VPWR _1017_ sky130_fd_sc_hd__a22oi_1
XFILLER_0_45_327 VGND VGND VPWR VPWR sky130_fd_sc_hd__decap_3
XFILLER_0_45_349 VGND VGND VPWR VPWR sky130_fd_sc_hd__decap_6
X_2843_ _2015_ _2017_ _2018_ VGND VGND VPWR VPWR _2019_ sky130_fd_sc_hd__nand3_1
X_2774_ _1885_ _1876_ _1875_ VGND VGND VPWR VPWR _1951_ sky130_fd_sc_hd__a21bo_1
XFILLER_0_53_393 VPWR VGND VPWR VGND sky130_ef_sc_hd__decap_12
XFILLER_0_13_279 VGND VGND VPWR VPWR sky130_fd_sc_hd__fill_1
XFILLER_0_0_195 VGND VGND VPWR VPWR sky130_fd_sc_hd__fill_1
XTAP_430 VGND VPWR sky130_fd_sc_hd__tapvpwrvgnd_1
XTAP_441 VGND VPWR sky130_fd_sc_hd__tapvpwrvgnd_1
X_3326_ _0437_ _0428_ _0429_ VGND VGND VPWR VPWR _0439_ sky130_fd_sc_hd__nand3_1
XTAP_452 VGND VPWR sky130_fd_sc_hd__tapvpwrvgnd_1
XTAP_463 VGND VPWR sky130_fd_sc_hd__tapvpwrvgnd_1
XTAP_474 VGND VPWR sky130_fd_sc_hd__tapvpwrvgnd_1
XTAP_485 VGND VPWR sky130_fd_sc_hd__tapvpwrvgnd_1
XFILLER_0_28_80 VGND VGND VPWR VPWR sky130_fd_sc_hd__decap_4
XTAP_496 VGND VPWR sky130_fd_sc_hd__tapvpwrvgnd_1
X_3257_ _0250_ VGND VGND VPWR VPWR _0371_ sky130_fd_sc_hd__clkbuf_2
X_2208_ _1430_ _1431_ VGND VGND VPWR VPWR _1432_ sky130_fd_sc_hd__nand2_1
X_3188_ _0201_ _0264_ _0301_ _0302_ VGND VGND VPWR VPWR _0303_ sky130_fd_sc_hd__a211o_1
X_2139_ net40 add_tmp\[13\] VGND VGND VPWR VPWR _0951_ sky130_fd_sc_hd__nor2_1
XFILLER_0_24_27 VGND VGND VPWR VPWR sky130_fd_sc_hd__fill_1
XFILLER_0_39_165 VGND VGND VPWR VPWR sky130_fd_sc_hd__decap_3
XFILLER_0_40_15 VPWR VGND VPWR VGND sky130_ef_sc_hd__decap_12
XFILLER_0_35_393 VPWR VGND VPWR VGND sky130_ef_sc_hd__decap_12
X_2490_ _1654_ VGND VGND VPWR VPWR _1675_ sky130_fd_sc_hd__clkbuf_2
XFILLER_0_49_46 VGND VGND VPWR VPWR sky130_fd_sc_hd__decap_8
XFILLER_0_49_57 VGND VGND VPWR VPWR sky130_fd_sc_hd__decap_8
X_4160_ _1285_ _1244_ _1247_ VGND VGND VPWR VPWR _1306_ sky130_fd_sc_hd__a21o_1
XFILLER_0_4_15 VPWR VGND VPWR VGND sky130_ef_sc_hd__decap_12
X_3111_ _0151_ _0152_ _0220_ _0221_ VGND VGND VPWR VPWR _0227_ sky130_fd_sc_hd__a211oi_2
X_4091_ _1219_ _1220_ VGND VGND VPWR VPWR _1231_ sky130_fd_sc_hd__nand2_1
XFILLER_0_65_45 VGND VGND VPWR VPWR sky130_fd_sc_hd__decap_4
X_3042_ net23 VGND VGND VPWR VPWR _0158_ sky130_fd_sc_hd__clkbuf_2
X_3944_ _1068_ _1069_ _1071_ VGND VGND VPWR VPWR _1073_ sky130_fd_sc_hd__a21o_1
X_3875_ _0993_ _0995_ _0855_ VGND VGND VPWR VPWR _0998_ sky130_fd_sc_hd__a21o_1
XFILLER_0_45_124 VGND VGND VPWR VPWR sky130_fd_sc_hd__fill_1
X_2826_ _1896_ _1903_ _1999_ _2000_ VGND VGND VPWR VPWR _2002_ sky130_fd_sc_hd__o2bb2a_2
XFILLER_0_45_179 VGND VGND VPWR VPWR sky130_fd_sc_hd__decap_3
XFILLER_0_60_105 VPWR VGND VPWR VGND sky130_ef_sc_hd__decap_12
XFILLER_0_5_287 VGND VGND VPWR VPWR sky130_fd_sc_hd__decap_8
XFILLER_0_30_81 VGND VGND VPWR VPWR sky130_fd_sc_hd__decap_3
XFILLER_0_30_92 VPWR VGND VPWR VGND sky130_ef_sc_hd__decap_12
XFILLER_0_41_341 VGND VGND VPWR VPWR sky130_fd_sc_hd__fill_1
X_2757_ _1730_ VGND VGND VPWR VPWR _1934_ sky130_fd_sc_hd__clkbuf_2
X_2688_ _1720_ VGND VGND VPWR VPWR _1866_ sky130_fd_sc_hd__buf_6
XTAP_260 VGND VPWR sky130_fd_sc_hd__tapvpwrvgnd_1
XTAP_293 VGND VPWR sky130_fd_sc_hd__tapvpwrvgnd_1
XTAP_282 VGND VPWR sky130_fd_sc_hd__tapvpwrvgnd_1
XTAP_271 VGND VPWR sky130_fd_sc_hd__tapvpwrvgnd_1
X_4289_ clknet_3_2__leaf_clk _0034_ net35 VGND VGND VPWR VPWR net61 sky130_fd_sc_hd__dfrtp_4
X_3309_ _1658_ _1672_ _0332_ VGND VGND VPWR VPWR _0422_ sky130_fd_sc_hd__nand3_4
XFILLER_0_49_452 VGND VGND VPWR VPWR sky130_fd_sc_hd__decap_8
XFILLER_0_36_135 VGND VGND VPWR VPWR sky130_fd_sc_hd__fill_1
XFILLER_0_51_138 VPWR VGND VPWR VGND sky130_ef_sc_hd__decap_12
XFILLER_0_32_363 VGND VGND VPWR VPWR sky130_fd_sc_hd__fill_1
XFILLER_0_59_216 VGND VGND VPWR VPWR sky130_fd_sc_hd__decap_8
XFILLER_0_27_124 VPWR VGND VPWR VGND sky130_ef_sc_hd__decap_12
X_3660_ _0767_ _0768_ VGND VGND VPWR VPWR _0769_ sky130_fd_sc_hd__xnor2_1
X_3591_ _1962_ _0340_ _0699_ _0700_ VGND VGND VPWR VPWR _0701_ sky130_fd_sc_hd__nand4_2
X_2611_ _1789_ _1780_ _1781_ VGND VGND VPWR VPWR _1791_ sky130_fd_sc_hd__nand3_1
XFILLER_0_42_138 VGND VGND VPWR VPWR sky130_fd_sc_hd__fill_2
X_2542_ _1720_ _1721_ _1722_ _1723_ VGND VGND VPWR VPWR _1724_ sky130_fd_sc_hd__a22o_1
X_4212_ _1320_ _1328_ _1359_ _1361_ VGND VGND VPWR VPWR _1363_ sky130_fd_sc_hd__and4_1
X_2473_ _1658_ VGND VGND VPWR VPWR _1659_ sky130_fd_sc_hd__clkbuf_2
XFILLER_0_76_77 VGND VGND VPWR VPWR sky130_fd_sc_hd__decap_6
X_4143_ _0157_ _0160_ _1195_ VGND VGND VPWR VPWR _1288_ sky130_fd_sc_hd__and3_1
X_4074_ _1212_ _1213_ VGND VGND VPWR VPWR _1214_ sky130_fd_sc_hd__xnor2_1
X_3025_ _0138_ _0139_ _0140_ VGND VGND VPWR VPWR _0142_ sky130_fd_sc_hd__o21ba_1
XFILLER_0_46_433 VGND VGND VPWR VPWR sky130_fd_sc_hd__decap_8
X_3927_ add_tmp\[23\] _1053_ _1054_ VGND VGND VPWR VPWR _1055_ sky130_fd_sc_hd__mux2_1
X_3858_ _0830_ _0902_ _0979_ VGND VGND VPWR VPWR _0980_ sky130_fd_sc_hd__o21a_2
X_2809_ _1924_ _1985_ VGND VGND VPWR VPWR _1986_ sky130_fd_sc_hd__nor2_1
XFILLER_0_61_447 VGND VGND VPWR VPWR sky130_fd_sc_hd__fill_1
X_3789_ _0827_ _0809_ _0903_ VGND VGND VPWR VPWR _0905_ sky130_fd_sc_hd__and3_1
XFILLER_0_49_293 VPWR VGND VPWR VGND sky130_ef_sc_hd__decap_12
XFILLER_0_24_105 VGND VGND VPWR VPWR sky130_fd_sc_hd__decap_8
XFILLER_0_62_68 VGND VGND VPWR VPWR sky130_fd_sc_hd__decap_3
XFILLER_0_7_305 VGND VGND VPWR VPWR sky130_fd_sc_hd__decap_6
XFILLER_0_15_127 VPWR VGND VPWR VGND sky130_ef_sc_hd__decap_12
XFILLER_0_7_349 VPWR VGND VPWR VGND sky130_ef_sc_hd__decap_12
XFILLER_0_55_274 VGND VGND VPWR VPWR sky130_fd_sc_hd__decap_6
X_3712_ _0664_ _0819_ _0820_ _0735_ VGND VGND VPWR VPWR _0822_ sky130_fd_sc_hd__o22a_1
XFILLER_0_43_447 VGND VGND VPWR VPWR sky130_fd_sc_hd__fill_1
X_3643_ _0672_ _0751_ VGND VGND VPWR VPWR _0752_ sky130_fd_sc_hd__xnor2_1
XFILLER_0_11_61 VGND VGND VPWR VPWR sky130_fd_sc_hd__fill_2
X_3574_ _0191_ _2063_ _0681_ _0682_ VGND VGND VPWR VPWR _0684_ sky130_fd_sc_hd__a22o_1
X_2525_ _1663_ _1707_ VGND VGND VPWR VPWR _1708_ sky130_fd_sc_hd__nand2_1
X_2456_ _1643_ _1644_ _1634_ VGND VGND VPWR VPWR _1645_ sky130_fd_sc_hd__o21ai_1
X_4126_ _1268_ _1269_ VGND VGND VPWR VPWR _1270_ sky130_fd_sc_hd__xor2_1
X_2387_ net48 _1588_ _1553_ VGND VGND VPWR VPWR _1589_ sky130_fd_sc_hd__mux2_1
X_4057_ _1141_ VGND VGND VPWR VPWR _1195_ sky130_fd_sc_hd__dlymetal6s2s_1
X_3008_ _0122_ _0123_ _0124_ VGND VGND VPWR VPWR _0125_ sky130_fd_sc_hd__nand3_1
XFILLER_0_19_411 VGND VGND VPWR VPWR sky130_fd_sc_hd__decap_4
XFILLER_0_34_447 VPWR VGND VPWR VGND sky130_ef_sc_hd__decap_12
XFILLER_0_69_300 VPWR VGND VPWR VGND sky130_ef_sc_hd__decap_12
XFILLER_0_32_49 VGND VGND VPWR VPWR sky130_fd_sc_hd__fill_1
XFILLER_0_37_252 VGND VGND VPWR VPWR sky130_fd_sc_hd__fill_1
XFILLER_0_52_277 VGND VGND VPWR VPWR sky130_fd_sc_hd__fill_1
XFILLER_0_20_141 VPWR VGND VPWR VGND sky130_ef_sc_hd__decap_12
X_3290_ _1664_ _0403_ VGND VGND VPWR VPWR _0404_ sky130_fd_sc_hd__nor2_2
X_2310_ _1243_ _1525_ VGND VGND VPWR VPWR _1526_ sky130_fd_sc_hd__nand2_1
XFILLER_0_57_35 VGND VGND VPWR VPWR sky130_fd_sc_hd__decap_4
X_2241_ _1461_ _1464_ VGND VGND VPWR VPWR _1465_ sky130_fd_sc_hd__or2_1
XFILLER_0_57_57 VPWR VGND VPWR VGND sky130_ef_sc_hd__decap_12
X_2172_ net71 add_tmp\[9\] VGND VGND VPWR VPWR _1308_ sky130_fd_sc_hd__nand2_1
XFILLER_0_73_89 VGND VGND VPWR VPWR sky130_fd_sc_hd__fill_2
XFILLER_0_75_325 VGND VGND VPWR VPWR sky130_fd_sc_hd__fill_2
XFILLER_0_7_102 VGND VGND VPWR VPWR sky130_fd_sc_hd__decap_3
XFILLER_0_28_230 VGND VGND VPWR VPWR sky130_fd_sc_hd__fill_1
XFILLER_0_7_157 VGND VGND VPWR VPWR sky130_fd_sc_hd__fill_2
XFILLER_0_16_436 VPWR VGND VPWR VGND sky130_ef_sc_hd__decap_12
X_3626_ _0734_ _0735_ VGND VGND VPWR VPWR _0736_ sky130_fd_sc_hd__nor2_1
X_3557_ _0667_ VGND VGND VPWR VPWR _0056_ sky130_fd_sc_hd__clkbuf_1
XFILLER_0_11_130 VGND VGND VPWR VPWR sky130_fd_sc_hd__decap_6
XFILLER_0_11_152 VGND VGND VPWR VPWR sky130_fd_sc_hd__decap_4
X_2508_ _1676_ _1689_ _1691_ VGND VGND VPWR VPWR _1692_ sky130_fd_sc_hd__o21a_1
X_3488_ _0559_ _0577_ _0578_ VGND VGND VPWR VPWR _0599_ sky130_fd_sc_hd__nor3_1
X_2439_ net59 _1630_ _1597_ VGND VGND VPWR VPWR _1631_ sky130_fd_sc_hd__mux2_1
X_4109_ _1249_ _1250_ VGND VGND VPWR VPWR _1251_ sky130_fd_sc_hd__nor2_1
XPHY_103 VGND VGND VPWR VPWR sky130_fd_sc_hd__decap_3
XPHY_114 VGND VGND VPWR VPWR sky130_fd_sc_hd__decap_3
XPHY_125 VGND VGND VPWR VPWR sky130_fd_sc_hd__decap_3
XPHY_136 VGND VGND VPWR VPWR sky130_fd_sc_hd__decap_3
XPHY_147 VGND VGND VPWR VPWR sky130_fd_sc_hd__decap_3
XPHY_5 VGND VGND VPWR VPWR sky130_fd_sc_hd__decap_3
XFILLER_0_25_222 VGND VGND VPWR VPWR sky130_fd_sc_hd__fill_2
X_2790_ _1952_ _1953_ net106 VGND VGND VPWR VPWR _1967_ sky130_fd_sc_hd__a21o_1
XFILLER_0_65_391 VGND VGND VPWR VPWR sky130_fd_sc_hd__fill_1
XFILLER_0_4_116 VPWR VGND VPWR VGND sky130_ef_sc_hd__decap_12
XFILLER_0_25_277 VGND VGND VPWR VPWR sky130_fd_sc_hd__decap_3
XFILLER_0_7_15 VPWR VGND VPWR VGND sky130_ef_sc_hd__decap_12
XFILLER_0_40_225 VGND VGND VPWR VPWR sky130_fd_sc_hd__decap_3
XFILLER_0_40_236 VGND VGND VPWR VPWR sky130_fd_sc_hd__decap_8
XFILLER_0_7_48 VGND VGND VPWR VPWR sky130_fd_sc_hd__decap_8
X_3411_ _0518_ _0522_ VGND VGND VPWR VPWR _0523_ sky130_fd_sc_hd__nor2_1
X_3342_ _0441_ _0442_ _0454_ VGND VGND VPWR VPWR _0455_ sky130_fd_sc_hd__a21oi_1
XTAP_601 VGND VPWR sky130_fd_sc_hd__tapvpwrvgnd_1
XTAP_612 VGND VPWR sky130_fd_sc_hd__tapvpwrvgnd_1
XTAP_623 VGND VPWR sky130_fd_sc_hd__tapvpwrvgnd_1
XTAP_634 VGND VPWR sky130_fd_sc_hd__tapvpwrvgnd_1
XTAP_645 VGND VPWR sky130_fd_sc_hd__tapvpwrvgnd_1
XTAP_656 VGND VPWR sky130_fd_sc_hd__tapvpwrvgnd_1
XTAP_667 VGND VPWR sky130_fd_sc_hd__tapvpwrvgnd_1
X_3273_ _0367_ _0385_ _0386_ VGND VGND VPWR VPWR _0387_ sky130_fd_sc_hd__and3_1
X_2224_ _1440_ _1447_ VGND VGND VPWR VPWR _1448_ sky130_fd_sc_hd__or2_1
XTAP_678 VGND VPWR sky130_fd_sc_hd__tapvpwrvgnd_1
XTAP_689 VGND VPWR sky130_fd_sc_hd__tapvpwrvgnd_1
X_2155_ net36 add_tmp\[0\] VGND VGND VPWR VPWR _1124_ sky130_fd_sc_hd__and2_1
XFILLER_0_48_358 VGND VGND VPWR VPWR sky130_fd_sc_hd__decap_6
XFILLER_0_8_433 VPWR VGND VPWR VGND sky130_ef_sc_hd__decap_12
XFILLER_0_63_328 VGND VGND VPWR VPWR sky130_fd_sc_hd__decap_8
X_2988_ _0098_ _0104_ VGND VGND VPWR VPWR _0105_ sky130_fd_sc_hd__xor2_1
XFILLER_0_31_225 VGND VGND VPWR VPWR sky130_fd_sc_hd__decap_4
X_3609_ _0717_ _0718_ VGND VGND VPWR VPWR _0719_ sky130_fd_sc_hd__or2b_1
XFILLER_0_3_182 VPWR VGND VPWR VGND sky130_ef_sc_hd__decap_12
XFILLER_0_66_188 VGND VGND VPWR VPWR sky130_fd_sc_hd__decap_4
XFILLER_0_47_380 VGND VGND VPWR VPWR sky130_fd_sc_hd__decap_4
XFILLER_0_62_383 VPWR VGND VPWR VGND sky130_ef_sc_hd__decap_12
XFILLER_0_1_108 VGND VGND VPWR VPWR sky130_fd_sc_hd__decap_4
X_3960_ _1080_ _1082_ _1089_ VGND VGND VPWR VPWR _1090_ sky130_fd_sc_hd__a21oi_1
XFILLER_0_57_111 VGND VGND VPWR VPWR sky130_fd_sc_hd__fill_1
X_2911_ _2008_ _2085_ VGND VGND VPWR VPWR _2086_ sky130_fd_sc_hd__nand2_1
XFILLER_0_57_133 VPWR VGND VPWR VGND sky130_ef_sc_hd__decap_12
X_3891_ _1012_ _1013_ _0915_ _0916_ VGND VGND VPWR VPWR _1015_ sky130_fd_sc_hd__o211ai_2
XFILLER_0_57_166 VGND VGND VPWR VPWR sky130_fd_sc_hd__fill_2
XFILLER_0_70_46 VGND VGND VPWR VPWR sky130_fd_sc_hd__fill_2
X_2842_ _1693_ _1939_ _2016_ _1657_ VGND VGND VPWR VPWR _2018_ sky130_fd_sc_hd__a22o_1
X_2773_ _1947_ _1948_ _1933_ VGND VGND VPWR VPWR _1950_ sky130_fd_sc_hd__a21o_1
XFILLER_0_13_225 VPWR VGND VPWR VGND sky130_ef_sc_hd__decap_12
XFILLER_0_0_141 VGND VGND VPWR VPWR sky130_fd_sc_hd__fill_2
XTAP_420 VGND VPWR sky130_fd_sc_hd__tapvpwrvgnd_1
XTAP_431 VGND VPWR sky130_fd_sc_hd__tapvpwrvgnd_1
XTAP_442 VGND VPWR sky130_fd_sc_hd__tapvpwrvgnd_1
X_3325_ _0428_ _0429_ _0437_ VGND VGND VPWR VPWR _0438_ sky130_fd_sc_hd__a21o_1
XTAP_453 VGND VPWR sky130_fd_sc_hd__tapvpwrvgnd_1
XTAP_464 VGND VPWR sky130_fd_sc_hd__tapvpwrvgnd_1
XTAP_475 VGND VPWR sky130_fd_sc_hd__tapvpwrvgnd_1
X_3256_ _1997_ _0290_ _0208_ _0369_ VGND VGND VPWR VPWR _0370_ sky130_fd_sc_hd__nand4_2
XTAP_486 VGND VPWR sky130_fd_sc_hd__tapvpwrvgnd_1
XTAP_497 VGND VPWR sky130_fd_sc_hd__tapvpwrvgnd_1
X_2207_ net48 add_tmp\[20\] VGND VGND VPWR VPWR _1431_ sky130_fd_sc_hd__or2_1
XFILLER_0_21_3 VPWR VGND VPWR VGND sky130_ef_sc_hd__decap_12
X_3187_ _0300_ _0287_ _0288_ VGND VGND VPWR VPWR _0302_ sky130_fd_sc_hd__and3_1
X_2138_ _0918_ _0929_ VGND VGND VPWR VPWR _0940_ sky130_fd_sc_hd__nand2_1
XFILLER_0_48_111 VPWR VGND VPWR VGND sky130_ef_sc_hd__decap_12
XFILLER_0_36_317 VGND VGND VPWR VPWR sky130_fd_sc_hd__decap_3
XFILLER_0_8_274 VPWR VGND VPWR VGND sky130_ef_sc_hd__decap_12
XFILLER_0_63_169 VGND VGND VPWR VPWR sky130_fd_sc_hd__decap_3
XFILLER_0_44_372 VGND VGND VPWR VPWR sky130_fd_sc_hd__decap_3
XFILLER_0_39_111 VGND VGND VPWR VPWR sky130_fd_sc_hd__fill_1
XFILLER_0_39_144 VGND VGND VPWR VPWR sky130_fd_sc_hd__decap_6
XFILLER_0_27_306 VGND VGND VPWR VPWR sky130_fd_sc_hd__fill_1
XFILLER_0_40_27 VGND VGND VPWR VPWR sky130_fd_sc_hd__fill_1
XFILLER_0_35_350 VPWR VGND VPWR VGND sky130_ef_sc_hd__decap_12
XFILLER_0_42_309 VGND VGND VPWR VPWR sky130_fd_sc_hd__decap_8
XFILLER_0_50_375 VPWR VGND VPWR VGND sky130_ef_sc_hd__decap_12
XFILLER_0_4_27 VGND VGND VPWR VPWR sky130_fd_sc_hd__fill_1
X_3110_ _0222_ _0223_ _0225_ VGND VGND VPWR VPWR _0226_ sky130_fd_sc_hd__a21bo_1
X_4090_ _1229_ _1230_ add_tmp\[26\] _1712_ VGND VGND VPWR VPWR _0064_ sky130_fd_sc_hd__a2bb2o_1
X_3041_ _0156_ VGND VGND VPWR VPWR _0157_ sky130_fd_sc_hd__clkbuf_2
XFILLER_0_14_61 VPWR VGND VPWR VGND sky130_ef_sc_hd__decap_12
X_3943_ _1068_ _1069_ _1071_ VGND VGND VPWR VPWR _1072_ sky130_fd_sc_hd__nand3_1
X_3874_ _0996_ VGND VGND VPWR VPWR _0997_ sky130_fd_sc_hd__buf_1
Xclkbuf_3_2__f_clk clknet_0_clk VGND VGND VPWR VPWR clknet_3_2__leaf_clk sky130_fd_sc_hd__clkbuf_16
XFILLER_0_26_350 VPWR VGND VPWR VGND sky130_ef_sc_hd__decap_12
X_2825_ _1999_ _2000_ _1896_ _1903_ VGND VGND VPWR VPWR _2001_ sky130_fd_sc_hd__and4bb_1
XFILLER_0_60_117 VPWR VGND VPWR VGND sky130_ef_sc_hd__decap_12
X_2756_ _1928_ _1932_ VGND VGND VPWR VPWR _1933_ sky130_fd_sc_hd__xor2_2
X_2687_ _1685_ _1829_ VGND VGND VPWR VPWR _1865_ sky130_fd_sc_hd__and2_1
XFILLER_0_1_461 VGND VGND VPWR VPWR sky130_fd_sc_hd__fill_2
XFILLER_0_69_3 VPWR VGND VPWR VGND sky130_ef_sc_hd__decap_12
XTAP_250 VGND VPWR sky130_fd_sc_hd__tapvpwrvgnd_1
XTAP_283 VGND VPWR sky130_fd_sc_hd__tapvpwrvgnd_1
XTAP_272 VGND VPWR sky130_fd_sc_hd__tapvpwrvgnd_1
XTAP_261 VGND VPWR sky130_fd_sc_hd__tapvpwrvgnd_1
X_4288_ clknet_3_0__leaf_clk _0033_ net35 VGND VGND VPWR VPWR net60 sky130_fd_sc_hd__dfrtp_4
X_3308_ _0362_ _0350_ _0351_ VGND VGND VPWR VPWR _0421_ sky130_fd_sc_hd__nand3_1
XTAP_294 VGND VPWR sky130_fd_sc_hd__tapvpwrvgnd_1
X_3239_ _1798_ _1940_ _2093_ _1759_ VGND VGND VPWR VPWR _0353_ sky130_fd_sc_hd__a22o_1
XFILLER_0_76_272 VPWR VGND VPWR VGND sky130_ef_sc_hd__decap_12
XFILLER_0_24_309 VGND VGND VPWR VPWR sky130_fd_sc_hd__decap_4
XFILLER_0_10_19 VGND VGND VPWR VPWR sky130_fd_sc_hd__decap_4
XFILLER_0_35_16 VPWR VGND VPWR VGND sky130_ef_sc_hd__decap_12
XFILLER_0_59_228 VPWR VGND VPWR VGND sky130_ef_sc_hd__decap_12
XFILLER_0_55_423 VGND VGND VPWR VPWR sky130_fd_sc_hd__fill_1
XFILLER_0_15_309 VGND VGND VPWR VPWR sky130_fd_sc_hd__fill_1
XFILLER_0_27_136 VGND VGND VPWR VPWR sky130_fd_sc_hd__fill_2
XFILLER_0_55_445 VGND VGND VPWR VPWR sky130_fd_sc_hd__decap_3
X_2610_ _1780_ _1781_ _1789_ VGND VGND VPWR VPWR _1790_ sky130_fd_sc_hd__a21o_1
X_3590_ _2077_ _1820_ _0120_ _0181_ VGND VGND VPWR VPWR _0700_ sky130_fd_sc_hd__nand4_2
XFILLER_0_2_247 VGND VGND VPWR VPWR sky130_fd_sc_hd__decap_4
X_2541_ net19 VGND VGND VPWR VPWR _1723_ sky130_fd_sc_hd__buf_6
XFILLER_0_2_269 VGND VGND VPWR VPWR sky130_fd_sc_hd__decap_4
X_2472_ _1657_ VGND VGND VPWR VPWR _1658_ sky130_fd_sc_hd__clkbuf_2
X_4211_ _1360_ VGND VGND VPWR VPWR _1361_ sky130_fd_sc_hd__inv_2
X_4142_ _0080_ _0160_ _1195_ VGND VGND VPWR VPWR _1287_ sky130_fd_sc_hd__o21ai_1
X_4073_ _0912_ _0747_ VGND VGND VPWR VPWR _1213_ sky130_fd_sc_hd__or2_1
X_3024_ _0138_ net101 _0140_ VGND VGND VPWR VPWR _0141_ sky130_fd_sc_hd__nor3b_2
XFILLER_0_58_294 VGND VGND VPWR VPWR sky130_fd_sc_hd__fill_1
X_3926_ _1489_ VGND VGND VPWR VPWR _1054_ sky130_fd_sc_hd__buf_2
XFILLER_0_33_117 VGND VGND VPWR VPWR sky130_fd_sc_hd__decap_6
X_3857_ _0896_ _0898_ _0901_ VGND VGND VPWR VPWR _0979_ sky130_fd_sc_hd__or3b_1
XFILLER_0_73_264 VGND VGND VPWR VPWR sky130_fd_sc_hd__fill_1
XFILLER_0_26_180 VPWR VGND VPWR VGND sky130_ef_sc_hd__decap_12
X_2808_ _1982_ _1984_ VGND VGND VPWR VPWR _1985_ sky130_fd_sc_hd__xor2_1
X_3788_ _0827_ _0809_ _0903_ VGND VGND VPWR VPWR _0904_ sky130_fd_sc_hd__a21oi_1
X_2739_ _1913_ _1914_ _1916_ VGND VGND VPWR VPWR _1917_ sky130_fd_sc_hd__nand3_1
XFILLER_0_41_161 VGND VGND VPWR VPWR sky130_fd_sc_hd__fill_1
XFILLER_0_64_253 VGND VGND VPWR VPWR sky130_fd_sc_hd__decap_6
XFILLER_0_52_404 VPWR VGND VPWR VGND sky130_ef_sc_hd__decap_12
XFILLER_0_17_191 VGND VGND VPWR VPWR sky130_fd_sc_hd__decap_3
XFILLER_0_20_334 VPWR VGND VPWR VGND sky130_ef_sc_hd__decap_12
XFILLER_0_46_37 VPWR VGND VPWR VGND sky130_ef_sc_hd__decap_12
X_3711_ _0737_ _0733_ VGND VGND VPWR VPWR _0820_ sky130_fd_sc_hd__and2b_1
XFILLER_0_15_139 VPWR VGND VPWR VGND sky130_ef_sc_hd__decap_12
X_3642_ _0743_ _0750_ VGND VGND VPWR VPWR _0751_ sky130_fd_sc_hd__xnor2_1
XFILLER_0_55_297 VGND VGND VPWR VPWR sky130_fd_sc_hd__decap_8
XFILLER_0_70_256 VGND VGND VPWR VPWR sky130_fd_sc_hd__decap_6
X_3573_ _0357_ _0164_ _0681_ _0682_ VGND VGND VPWR VPWR _0683_ sky130_fd_sc_hd__nand4_2
X_2524_ _1706_ VGND VGND VPWR VPWR _1707_ sky130_fd_sc_hd__buf_2
XFILLER_0_60_7 VGND VGND VPWR VPWR sky130_fd_sc_hd__fill_1
X_2455_ _1474_ _1475_ _1639_ _1516_ VGND VGND VPWR VPWR _1644_ sky130_fd_sc_hd__a31o_1
X_2386_ _1587_ add_tmp\[20\] _1577_ VGND VGND VPWR VPWR _1588_ sky130_fd_sc_hd__mux2_1
X_4125_ _1210_ _1214_ _1216_ VGND VGND VPWR VPWR _1269_ sky130_fd_sc_hd__a21o_1
X_4056_ _1143_ _1193_ _1140_ VGND VGND VPWR VPWR _1194_ sky130_fd_sc_hd__a21o_1
X_3007_ _2091_ _2097_ _2095_ VGND VGND VPWR VPWR _0124_ sky130_fd_sc_hd__a21bo_1
X_3909_ _0755_ _0403_ VGND VGND VPWR VPWR _1035_ sky130_fd_sc_hd__nor2_1
XFILLER_0_61_201 VPWR VGND VPWR VGND sky130_ef_sc_hd__decap_12
XFILLER_0_34_459 VGND VGND VPWR VPWR sky130_fd_sc_hd__decap_4
XFILLER_0_16_29 VGND VGND VPWR VPWR sky130_fd_sc_hd__decap_8
XFILLER_0_69_312 VPWR VGND VPWR VGND sky130_ef_sc_hd__decap_12
XFILLER_0_4_309 VPWR VGND VPWR VGND sky130_ef_sc_hd__decap_12
XFILLER_0_52_223 VGND VGND VPWR VPWR sky130_fd_sc_hd__decap_3
XFILLER_0_20_153 VGND VGND VPWR VPWR sky130_fd_sc_hd__decap_6
X_2240_ _1462_ _1463_ VGND VGND VPWR VPWR _1464_ sky130_fd_sc_hd__nand2_1
XFILLER_0_57_69 VPWR VGND VPWR VGND sky130_ef_sc_hd__decap_12
X_2171_ _1038_ _1276_ _1286_ VGND VGND VPWR VPWR _1297_ sky130_fd_sc_hd__o21a_1
XFILLER_0_73_57 VPWR VGND VPWR VGND sky130_ef_sc_hd__decap_12
XFILLER_0_16_415 VGND VGND VPWR VPWR sky130_fd_sc_hd__fill_2
XFILLER_0_28_264 VPWR VGND VPWR VGND sky130_ef_sc_hd__decap_12
XFILLER_0_16_448 VPWR VGND VPWR VGND sky130_ef_sc_hd__decap_12
X_3625_ _0668_ _0669_ _0732_ VGND VGND VPWR VPWR _0735_ sky130_fd_sc_hd__and3_1
X_3556_ add_tmp\[18\] _0666_ _0596_ VGND VGND VPWR VPWR _0667_ sky130_fd_sc_hd__mux2_1
X_2507_ _1489_ VGND VGND VPWR VPWR _1691_ sky130_fd_sc_hd__buf_2
X_3487_ _0516_ _0526_ _0525_ VGND VGND VPWR VPWR _0598_ sky130_fd_sc_hd__a21o_1
XFILLER_0_51_3 VGND VGND VPWR VPWR sky130_fd_sc_hd__fill_2
X_2438_ _1514_ add_tmp\[30\] _1627_ _1629_ VGND VGND VPWR VPWR _1630_ sky130_fd_sc_hd__a22o_1
X_2369_ _1486_ _1573_ VGND VGND VPWR VPWR _1574_ sky130_fd_sc_hd__nor2_1
X_4108_ _1184_ _1248_ VGND VGND VPWR VPWR _1250_ sky130_fd_sc_hd__nor2_1
X_4039_ _1174_ _1175_ VGND VGND VPWR VPWR _1176_ sky130_fd_sc_hd__or2b_1
XFILLER_0_2_82 VGND VGND VPWR VPWR sky130_fd_sc_hd__fill_2
XPHY_104 VGND VGND VPWR VPWR sky130_fd_sc_hd__decap_3
XPHY_115 VGND VGND VPWR VPWR sky130_fd_sc_hd__decap_3
XFILLER_0_66_304 VGND VGND VPWR VPWR sky130_fd_sc_hd__fill_1
XPHY_126 VGND VGND VPWR VPWR sky130_fd_sc_hd__decap_3
XPHY_137 VGND VGND VPWR VPWR sky130_fd_sc_hd__decap_3
XPHY_148 VGND VGND VPWR VPWR sky130_fd_sc_hd__decap_3
XFILLER_0_30_440 VPWR VGND VPWR VGND sky130_ef_sc_hd__decap_12
XFILLER_0_69_153 VPWR VGND VPWR VGND sky130_ef_sc_hd__decap_12
XPHY_6 VGND VGND VPWR VPWR sky130_fd_sc_hd__decap_3
XFILLER_0_69_175 VGND VGND VPWR VPWR sky130_fd_sc_hd__fill_1
XFILLER_0_57_337 VGND VGND VPWR VPWR sky130_fd_sc_hd__decap_4
XFILLER_0_4_128 VPWR VGND VPWR VGND sky130_ef_sc_hd__decap_12
XFILLER_0_7_27 VGND VGND VPWR VPWR sky130_fd_sc_hd__decap_6
X_3410_ _1681_ _0520_ _0475_ _0521_ _0474_ VGND VGND VPWR VPWR _0522_ sky130_fd_sc_hd__a311oi_2
X_3341_ _0443_ _0453_ VGND VGND VPWR VPWR _0454_ sky130_fd_sc_hd__xnor2_1
XFILLER_0_0_378 VGND VGND VPWR VPWR sky130_fd_sc_hd__decap_3
XTAP_602 VGND VPWR sky130_fd_sc_hd__tapvpwrvgnd_1
XTAP_613 VGND VPWR sky130_fd_sc_hd__tapvpwrvgnd_1
XTAP_624 VGND VPWR sky130_fd_sc_hd__tapvpwrvgnd_1
XTAP_635 VGND VPWR sky130_fd_sc_hd__tapvpwrvgnd_1
XTAP_646 VGND VPWR sky130_fd_sc_hd__tapvpwrvgnd_1
XTAP_657 VGND VPWR sky130_fd_sc_hd__tapvpwrvgnd_1
XTAP_668 VGND VPWR sky130_fd_sc_hd__tapvpwrvgnd_1
X_3272_ _0384_ _0378_ _0379_ VGND VGND VPWR VPWR _0386_ sky130_fd_sc_hd__nand3_2
X_2223_ _1443_ _1446_ VGND VGND VPWR VPWR _1447_ sky130_fd_sc_hd__or2_1
XTAP_679 VGND VPWR sky130_fd_sc_hd__tapvpwrvgnd_1
X_2154_ net47 add_tmp\[1\] VGND VGND VPWR VPWR _1114_ sky130_fd_sc_hd__or2_1
XFILLER_0_17_72 VGND VGND VPWR VPWR sky130_fd_sc_hd__fill_2
XFILLER_0_75_167 VGND VGND VPWR VPWR sky130_fd_sc_hd__fill_1
XFILLER_0_8_445 VPWR VGND VPWR VGND sky130_ef_sc_hd__decap_12
X_2987_ _0099_ _0103_ VGND VGND VPWR VPWR _0104_ sky130_fd_sc_hd__xor2_2
XFILLER_0_71_373 VGND VGND VPWR VPWR sky130_fd_sc_hd__decap_8
X_3608_ _0706_ _0707_ _0715_ _0716_ VGND VGND VPWR VPWR _0718_ sky130_fd_sc_hd__or4_4
XFILLER_0_3_194 VPWR VGND VPWR VGND sky130_ef_sc_hd__decap_12
X_3539_ _0539_ _0533_ _0649_ VGND VGND VPWR VPWR _0650_ sky130_fd_sc_hd__a21oi_2
XFILLER_0_39_326 VGND VGND VPWR VPWR sky130_fd_sc_hd__fill_1
XFILLER_0_39_337 VPWR VGND VPWR VGND sky130_ef_sc_hd__decap_12
XFILLER_0_54_307 VGND VGND VPWR VPWR sky130_fd_sc_hd__fill_1
XFILLER_0_62_373 VGND VGND VPWR VPWR sky130_fd_sc_hd__decap_6
XFILLER_0_62_395 VPWR VGND VPWR VGND sky130_ef_sc_hd__decap_12
XFILLER_0_38_27 VGND VGND VPWR VPWR sky130_fd_sc_hd__fill_1
XFILLER_0_54_15 VPWR VGND VPWR VGND sky130_ef_sc_hd__decap_12
X_2910_ _1996_ VGND VGND VPWR VPWR _2085_ sky130_fd_sc_hd__clkbuf_2
XFILLER_0_57_145 VGND VGND VPWR VPWR sky130_fd_sc_hd__decap_6
X_3890_ _0915_ _0916_ _1012_ _1013_ VGND VGND VPWR VPWR _1014_ sky130_fd_sc_hd__a211o_1
XFILLER_0_45_307 VGND VGND VPWR VPWR sky130_fd_sc_hd__decap_8
XFILLER_0_57_156 VGND VGND VPWR VPWR sky130_fd_sc_hd__decap_4
X_2841_ _1936_ _1866_ _1942_ _2016_ VGND VGND VPWR VPWR _2017_ sky130_fd_sc_hd__nand4_2
XFILLER_0_72_126 VPWR VGND VPWR VGND sky130_ef_sc_hd__decap_12
X_2772_ _1933_ _1947_ _1948_ VGND VGND VPWR VPWR _1949_ sky130_fd_sc_hd__nand3_1
XFILLER_0_13_259 VGND VGND VPWR VPWR sky130_fd_sc_hd__fill_2
XFILLER_0_13_237 VGND VGND VPWR VPWR sky130_fd_sc_hd__fill_2
XFILLER_0_0_131 VGND VGND VPWR VPWR sky130_fd_sc_hd__decap_8
XFILLER_0_0_197 VGND VGND VPWR VPWR sky130_fd_sc_hd__fill_2
XFILLER_0_0_175 VPWR VGND VPWR VGND sky130_ef_sc_hd__decap_12
XTAP_410 VGND VPWR sky130_fd_sc_hd__tapvpwrvgnd_1
XTAP_421 VGND VPWR sky130_fd_sc_hd__tapvpwrvgnd_1
XTAP_432 VGND VPWR sky130_fd_sc_hd__tapvpwrvgnd_1
X_3324_ _0432_ _0436_ VGND VGND VPWR VPWR _0437_ sky130_fd_sc_hd__xor2_2
XTAP_443 VGND VPWR sky130_fd_sc_hd__tapvpwrvgnd_1
XTAP_454 VGND VPWR sky130_fd_sc_hd__tapvpwrvgnd_1
XTAP_465 VGND VPWR sky130_fd_sc_hd__tapvpwrvgnd_1
XTAP_476 VGND VPWR sky130_fd_sc_hd__tapvpwrvgnd_1
X_3255_ _0165_ VGND VGND VPWR VPWR _0369_ sky130_fd_sc_hd__buf_2
XTAP_487 VGND VPWR sky130_fd_sc_hd__tapvpwrvgnd_1
XTAP_498 VGND VPWR sky130_fd_sc_hd__tapvpwrvgnd_1
X_2206_ net48 add_tmp\[20\] VGND VGND VPWR VPWR _1430_ sky130_fd_sc_hd__nand2_2
X_3186_ _0287_ _0288_ _0300_ VGND VGND VPWR VPWR _0301_ sky130_fd_sc_hd__a21oi_1
XFILLER_0_14_3 VGND VGND VPWR VPWR sky130_fd_sc_hd__decap_4
X_2137_ net41 add_tmp\[14\] VGND VGND VPWR VPWR _0929_ sky130_fd_sc_hd__or2_1
XFILLER_0_76_421 VPWR VGND VPWR VGND sky130_ef_sc_hd__decap_12
XFILLER_0_44_81 VGND VGND VPWR VPWR sky130_fd_sc_hd__decap_3
XFILLER_0_44_92 VPWR VGND VPWR VGND sky130_ef_sc_hd__decap_12
XFILLER_0_48_123 VPWR VGND VPWR VGND sky130_ef_sc_hd__decap_12
XFILLER_0_36_307 VGND VGND VPWR VPWR sky130_fd_sc_hd__fill_1
XFILLER_0_48_145 VGND VGND VPWR VPWR sky130_fd_sc_hd__decap_4
XFILLER_0_8_253 VPWR VGND VPWR VGND sky130_ef_sc_hd__decap_12
XFILLER_0_36_329 VGND VGND VPWR VPWR sky130_fd_sc_hd__decap_8
XFILLER_0_8_286 VGND VGND VPWR VPWR sky130_fd_sc_hd__fill_1
XFILLER_0_63_159 VGND VGND VPWR VPWR sky130_fd_sc_hd__decap_8
XFILLER_0_44_362 VGND VGND VPWR VPWR sky130_fd_sc_hd__fill_2
XFILLER_0_71_181 VGND VGND VPWR VPWR sky130_fd_sc_hd__decap_6
XFILLER_0_8_70 VPWR VGND VPWR VGND sky130_ef_sc_hd__decap_12
XFILLER_0_24_29 VPWR VGND VPWR VGND sky130_ef_sc_hd__decap_12
XFILLER_0_54_104 VPWR VGND VPWR VGND sky130_ef_sc_hd__decap_12
XFILLER_0_35_362 VGND VGND VPWR VPWR sky130_fd_sc_hd__decap_4
XFILLER_0_2_418 VGND VGND VPWR VPWR sky130_fd_sc_hd__fill_2
XFILLER_0_62_170 VGND VGND VPWR VPWR sky130_fd_sc_hd__fill_1
XFILLER_0_62_181 VPWR VGND VPWR VGND sky130_ef_sc_hd__decap_12
XFILLER_0_50_387 VGND VGND VPWR VPWR sky130_fd_sc_hd__fill_1
X_3040_ _0155_ VGND VGND VPWR VPWR _0156_ sky130_fd_sc_hd__clkbuf_2
XFILLER_0_58_421 VPWR VGND VPWR VGND sky130_ef_sc_hd__decap_12
X_3942_ _2063_ _0857_ VGND VGND VPWR VPWR _1071_ sky130_fd_sc_hd__and2_1
XFILLER_0_18_329 VGND VGND VPWR VPWR sky130_fd_sc_hd__decap_4
XFILLER_0_14_73 VGND VGND VPWR VPWR sky130_fd_sc_hd__decap_8
X_3873_ _0856_ _0993_ _0995_ VGND VGND VPWR VPWR _0996_ sky130_fd_sc_hd__nand3_1
X_2824_ _1840_ _1897_ _1898_ _1694_ VGND VGND VPWR VPWR _2000_ sky130_fd_sc_hd__a22oi_2
XFILLER_0_26_362 VGND VGND VPWR VPWR sky130_fd_sc_hd__fill_2
XFILLER_0_60_129 VGND VGND VPWR VPWR sky130_fd_sc_hd__decap_8
X_2755_ _1929_ _1930_ _1931_ VGND VGND VPWR VPWR _1932_ sky130_fd_sc_hd__a21bo_1
X_2686_ _1863_ _1864_ net131 _1712_ VGND VGND VPWR VPWR _0045_ sky130_fd_sc_hd__a2bb2o_1
XTAP_251 VGND VPWR sky130_fd_sc_hd__tapvpwrvgnd_1
XTAP_240 VGND VPWR sky130_fd_sc_hd__tapvpwrvgnd_1
XFILLER_0_39_81 VPWR VGND VPWR VGND sky130_ef_sc_hd__decap_12
X_3307_ net99 VGND VGND VPWR VPWR _0420_ sky130_fd_sc_hd__inv_2
XTAP_284 VGND VPWR sky130_fd_sc_hd__tapvpwrvgnd_1
XTAP_273 VGND VPWR sky130_fd_sc_hd__tapvpwrvgnd_1
XTAP_262 VGND VPWR sky130_fd_sc_hd__tapvpwrvgnd_1
X_4287_ clknet_3_2__leaf_clk _0032_ net35 VGND VGND VPWR VPWR net59 sky130_fd_sc_hd__dfrtp_1
XTAP_295 VGND VPWR sky130_fd_sc_hd__tapvpwrvgnd_1
X_3238_ _0294_ _0296_ VGND VGND VPWR VPWR _0352_ sky130_fd_sc_hd__nand2_2
X_3169_ _0275_ _0276_ _0283_ VGND VGND VPWR VPWR _0284_ sky130_fd_sc_hd__a21o_1
XFILLER_0_64_402 VGND VGND VPWR VPWR sky130_fd_sc_hd__fill_1
XFILLER_0_76_284 VPWR VGND VPWR VGND sky130_ef_sc_hd__decap_12
XFILLER_0_36_115 VGND VGND VPWR VPWR sky130_fd_sc_hd__fill_1
XFILLER_0_17_384 VGND VGND VPWR VPWR sky130_fd_sc_hd__decap_8
XFILLER_0_19_29 VGND VGND VPWR VPWR sky130_fd_sc_hd__decap_8
XFILLER_0_3_3 VPWR VGND VPWR VGND sky130_ef_sc_hd__decap_12
XFILLER_0_35_28 VGND VGND VPWR VPWR sky130_fd_sc_hd__fill_2
XFILLER_0_67_251 VGND VGND VPWR VPWR sky130_fd_sc_hd__decap_8
XFILLER_0_55_457 VGND VGND VPWR VPWR sky130_fd_sc_hd__decap_3
XFILLER_0_35_181 VGND VGND VPWR VPWR sky130_fd_sc_hd__decap_6
X_2540_ net13 VGND VGND VPWR VPWR _1722_ sky130_fd_sc_hd__buf_6
X_2471_ net19 VGND VGND VPWR VPWR _1657_ sky130_fd_sc_hd__buf_6
XFILLER_0_76_13 VPWR VGND VPWR VGND sky130_ef_sc_hd__decap_12
X_4210_ _1315_ _1331_ _1358_ VGND VGND VPWR VPWR _1360_ sky130_fd_sc_hd__nor3_1
XFILLER_0_50_195 VGND VGND VPWR VPWR sky130_fd_sc_hd__fill_1
X_4141_ _1130_ VGND VGND VPWR VPWR _1285_ sky130_fd_sc_hd__dlymetal6s2s_1
X_4072_ _0912_ _0746_ _1136_ _1134_ VGND VGND VPWR VPWR _1212_ sky130_fd_sc_hd__a31o_1
X_3023_ _2070_ _2058_ VGND VGND VPWR VPWR _0140_ sky130_fd_sc_hd__and2b_1
XFILLER_0_58_251 VGND VGND VPWR VPWR sky130_fd_sc_hd__fill_1
XFILLER_0_18_104 VGND VGND VPWR VPWR sky130_fd_sc_hd__fill_1
X_3925_ _1050_ _1052_ VGND VGND VPWR VPWR _1053_ sky130_fd_sc_hd__xnor2_1
X_3856_ _0976_ _0977_ VGND VGND VPWR VPWR _0978_ sky130_fd_sc_hd__nand2_4
XFILLER_0_26_192 VGND VGND VPWR VPWR sky130_fd_sc_hd__decap_4
X_2807_ _1809_ _1860_ _1918_ _1983_ VGND VGND VPWR VPWR _1984_ sky130_fd_sc_hd__a31o_1
X_3787_ _0830_ _0902_ VGND VGND VPWR VPWR _0903_ sky130_fd_sc_hd__xnor2_1
XFILLER_0_61_449 VPWR VGND VPWR VGND sky130_ef_sc_hd__decap_12
XFILLER_0_14_365 VGND VGND VPWR VPWR sky130_fd_sc_hd__decap_4
X_2738_ _1801_ _1855_ _1915_ VGND VGND VPWR VPWR _1916_ sky130_fd_sc_hd__a21o_1
XFILLER_0_14_376 VGND VGND VPWR VPWR sky130_fd_sc_hd__fill_1
X_2669_ _1835_ _1836_ _1846_ VGND VGND VPWR VPWR _1848_ sky130_fd_sc_hd__a21o_1
XFILLER_0_37_446 VGND VGND VPWR VPWR sky130_fd_sc_hd__fill_2
XFILLER_0_52_416 VGND VGND VPWR VPWR sky130_fd_sc_hd__decap_4
XFILLER_0_20_346 VPWR VGND VPWR VGND sky130_ef_sc_hd__decap_12
XFILLER_0_62_15 VPWR VGND VPWR VGND sky130_ef_sc_hd__decap_12
XFILLER_0_28_402 VPWR VGND VPWR VGND sky130_ef_sc_hd__decap_12
X_3710_ _0735_ _0663_ _0733_ VGND VGND VPWR VPWR _0819_ sky130_fd_sc_hd__or3b_1
XFILLER_0_43_405 VGND VGND VPWR VPWR sky130_fd_sc_hd__decap_6
XFILLER_0_55_265 VGND VGND VPWR VPWR sky130_fd_sc_hd__fill_1
XFILLER_0_43_449 VPWR VGND VPWR VGND sky130_ef_sc_hd__decap_12
X_3641_ _0745_ _0749_ VGND VGND VPWR VPWR _0750_ sky130_fd_sc_hd__nor2_1
X_3572_ _0112_ _0460_ _0633_ _2036_ VGND VGND VPWR VPWR _0682_ sky130_fd_sc_hd__nand4_4
X_2523_ net28 VGND VGND VPWR VPWR _1706_ sky130_fd_sc_hd__dlymetal6s2s_1
X_2454_ _1475_ _1639_ _1474_ VGND VGND VPWR VPWR _1643_ sky130_fd_sc_hd__a21oi_1
X_2385_ _1585_ _1586_ VGND VGND VPWR VPWR _1587_ sky130_fd_sc_hd__nor2_1
X_4124_ _1266_ _1267_ VGND VGND VPWR VPWR _1268_ sky130_fd_sc_hd__xor2_1
Xinput1 clr VGND VGND VPWR VPWR net1 sky130_fd_sc_hd__clkbuf_1
X_4055_ _1975_ _2037_ _1141_ VGND VGND VPWR VPWR _1193_ sky130_fd_sc_hd__o21a_1
XFILLER_0_36_60 VGND VGND VPWR VPWR sky130_fd_sc_hd__fill_1
X_3006_ _0119_ _0121_ _0116_ VGND VGND VPWR VPWR _0123_ sky130_fd_sc_hd__a21o_1
X_3908_ _0755_ _0744_ _0922_ VGND VGND VPWR VPWR _1034_ sky130_fd_sc_hd__and3b_1
X_3839_ _0956_ _0957_ _0880_ _0883_ VGND VGND VPWR VPWR _0959_ sky130_fd_sc_hd__a211oi_2
XFILLER_0_61_213 VGND VGND VPWR VPWR sky130_fd_sc_hd__decap_8
XFILLER_0_14_195 VGND VGND VPWR VPWR sky130_fd_sc_hd__fill_1
XFILLER_0_69_324 VGND VGND VPWR VPWR sky130_fd_sc_hd__decap_3
XFILLER_0_37_232 VPWR VGND VPWR VGND sky130_ef_sc_hd__decap_12
X_2170_ net70 add_tmp\[8\] VGND VGND VPWR VPWR _1286_ sky130_fd_sc_hd__nand2_1
XFILLER_0_73_69 VPWR VGND VPWR VGND sky130_ef_sc_hd__decap_12
XFILLER_0_22_40 VPWR VGND VPWR VGND sky130_ef_sc_hd__decap_12
XFILLER_0_28_276 VPWR VGND VPWR VGND sky130_ef_sc_hd__decap_12
XFILLER_0_43_213 VGND VGND VPWR VPWR sky130_fd_sc_hd__decap_8
X_3624_ _0733_ VGND VGND VPWR VPWR _0734_ sky130_fd_sc_hd__inv_2
XFILLER_0_43_279 VGND VGND VPWR VPWR sky130_fd_sc_hd__fill_1
X_3555_ _0663_ _0665_ VGND VGND VPWR VPWR _0666_ sky130_fd_sc_hd__xor2_1
XFILLER_0_11_110 VGND VGND VPWR VPWR sky130_fd_sc_hd__fill_2
X_2506_ _1676_ _1689_ VGND VGND VPWR VPWR _1690_ sky130_fd_sc_hd__nand2_1
X_3486_ _0597_ VGND VGND VPWR VPWR _0055_ sky130_fd_sc_hd__clkbuf_1
X_2437_ _1516_ _1628_ VGND VGND VPWR VPWR _1629_ sky130_fd_sc_hd__nor2_1
XFILLER_0_44_3 VGND VGND VPWR VPWR sky130_fd_sc_hd__decap_4
X_2368_ _1407_ _1572_ VGND VGND VPWR VPWR _1573_ sky130_fd_sc_hd__xor2_1
X_4107_ _1184_ _1248_ VGND VGND VPWR VPWR _1249_ sky130_fd_sc_hd__and2_1
X_2299_ _1200_ _1081_ _1189_ _1516_ VGND VGND VPWR VPWR _1517_ sky130_fd_sc_hd__a31oi_1
X_4038_ _1172_ _1173_ _1121_ _1122_ VGND VGND VPWR VPWR _1175_ sky130_fd_sc_hd__a211o_1
XPHY_105 VGND VGND VPWR VPWR sky130_fd_sc_hd__decap_3
XPHY_116 VGND VGND VPWR VPWR sky130_fd_sc_hd__decap_3
XPHY_149 VGND VGND VPWR VPWR sky130_fd_sc_hd__decap_3
XFILLER_0_19_221 VGND VGND VPWR VPWR sky130_fd_sc_hd__decap_3
XPHY_127 VGND VGND VPWR VPWR sky130_fd_sc_hd__decap_3
XPHY_138 VGND VGND VPWR VPWR sky130_fd_sc_hd__decap_3
XFILLER_0_22_408 VPWR VGND VPWR VGND sky130_ef_sc_hd__decap_12
XFILLER_0_30_452 VGND VGND VPWR VPWR sky130_fd_sc_hd__decap_8
XFILLER_0_69_121 VGND VGND VPWR VPWR sky130_fd_sc_hd__fill_1
XPHY_7 VGND VGND VPWR VPWR sky130_fd_sc_hd__decap_3
XFILLER_0_57_305 VGND VGND VPWR VPWR sky130_fd_sc_hd__decap_4
XFILLER_0_65_371 VGND VGND VPWR VPWR sky130_fd_sc_hd__fill_1
XFILLER_0_0_335 VGND VGND VPWR VPWR sky130_fd_sc_hd__fill_1
X_3340_ _0451_ _0452_ VGND VGND VPWR VPWR _0453_ sky130_fd_sc_hd__or2b_1
XFILLER_0_0_357 VGND VGND VPWR VPWR sky130_fd_sc_hd__decap_6
XTAP_603 VGND VPWR sky130_fd_sc_hd__tapvpwrvgnd_1
XTAP_614 VGND VPWR sky130_fd_sc_hd__tapvpwrvgnd_1
XTAP_625 VGND VPWR sky130_fd_sc_hd__tapvpwrvgnd_1
XTAP_636 VGND VPWR sky130_fd_sc_hd__tapvpwrvgnd_1
XTAP_647 VGND VPWR sky130_fd_sc_hd__tapvpwrvgnd_1
XTAP_658 VGND VPWR sky130_fd_sc_hd__tapvpwrvgnd_1
X_3271_ _0378_ _0379_ _0384_ VGND VGND VPWR VPWR _0385_ sky130_fd_sc_hd__a21o_1
X_2222_ _1444_ _1445_ VGND VGND VPWR VPWR _1446_ sky130_fd_sc_hd__nand2_1
XTAP_669 VGND VPWR sky130_fd_sc_hd__tapvpwrvgnd_1
X_2153_ net58 add_tmp\[2\] VGND VGND VPWR VPWR _1103_ sky130_fd_sc_hd__nor2_1
XFILLER_0_75_113 VGND VGND VPWR VPWR sky130_fd_sc_hd__fill_1
XFILLER_0_63_308 VGND VGND VPWR VPWR sky130_fd_sc_hd__decap_8
XFILLER_0_8_457 VGND VGND VPWR VPWR sky130_fd_sc_hd__decap_6
X_2986_ _0100_ _0101_ _0102_ VGND VGND VPWR VPWR _0103_ sky130_fd_sc_hd__a21bo_1
XFILLER_0_3_140 VGND VGND VPWR VPWR sky130_fd_sc_hd__fill_1
X_3607_ _0706_ _0707_ _0715_ _0716_ VGND VGND VPWR VPWR _0717_ sky130_fd_sc_hd__o22a_1
X_3538_ _0117_ _1672_ _1686_ _0328_ VGND VGND VPWR VPWR _0649_ sky130_fd_sc_hd__and4_2
X_3469_ _0557_ _0558_ _0580_ VGND VGND VPWR VPWR _0581_ sky130_fd_sc_hd__a21oi_1
XFILLER_0_66_102 VGND VGND VPWR VPWR sky130_fd_sc_hd__decap_4
XFILLER_0_39_349 VPWR VGND VPWR VGND sky130_ef_sc_hd__decap_12
XFILLER_0_47_393 VPWR VGND VPWR VGND sky130_ef_sc_hd__decap_12
XFILLER_0_22_216 VGND VGND VPWR VPWR sky130_fd_sc_hd__decap_8
XFILLER_0_54_27 VGND VGND VPWR VPWR sky130_fd_sc_hd__fill_1
XFILLER_0_57_113 VPWR VGND VPWR VGND sky130_ef_sc_hd__decap_12
XFILLER_0_70_15 VPWR VGND VPWR VGND sky130_ef_sc_hd__decap_12
X_2840_ net4 VGND VGND VPWR VPWR _2016_ sky130_fd_sc_hd__clkbuf_2
XFILLER_0_38_382 VPWR VGND VPWR VGND sky130_ef_sc_hd__decap_12
XFILLER_0_72_138 VGND VGND VPWR VPWR sky130_fd_sc_hd__fill_2
X_2771_ _1944_ _1945_ _1946_ VGND VGND VPWR VPWR _1948_ sky130_fd_sc_hd__a21o_1
XFILLER_0_53_330 VGND VGND VPWR VPWR sky130_fd_sc_hd__decap_6
XFILLER_0_72_149 VGND VGND VPWR VPWR sky130_fd_sc_hd__fill_2
XFILLER_0_5_449 VPWR VGND VPWR VGND sky130_ef_sc_hd__decap_12
XTAP_400 VGND VPWR sky130_fd_sc_hd__tapvpwrvgnd_1
XFILLER_0_0_187 VGND VGND VPWR VPWR sky130_fd_sc_hd__decap_8
XTAP_411 VGND VPWR sky130_fd_sc_hd__tapvpwrvgnd_1
XTAP_422 VGND VPWR sky130_fd_sc_hd__tapvpwrvgnd_1
XTAP_433 VGND VPWR sky130_fd_sc_hd__tapvpwrvgnd_1
X_3323_ _0433_ _0434_ _0435_ VGND VGND VPWR VPWR _0436_ sky130_fd_sc_hd__a21bo_1
XTAP_444 VGND VPWR sky130_fd_sc_hd__tapvpwrvgnd_1
XTAP_455 VGND VPWR sky130_fd_sc_hd__tapvpwrvgnd_1
XTAP_466 VGND VPWR sky130_fd_sc_hd__tapvpwrvgnd_1
X_3254_ _0108_ _1962_ _0249_ _2085_ VGND VGND VPWR VPWR _0368_ sky130_fd_sc_hd__a22o_1
XTAP_477 VGND VPWR sky130_fd_sc_hd__tapvpwrvgnd_1
XTAP_488 VGND VPWR sky130_fd_sc_hd__tapvpwrvgnd_1
XTAP_499 VGND VPWR sky130_fd_sc_hd__tapvpwrvgnd_1
X_2205_ _1422_ _1428_ VGND VGND VPWR VPWR _1429_ sky130_fd_sc_hd__nand2_1
X_3185_ _0292_ _0299_ VGND VGND VPWR VPWR _0300_ sky130_fd_sc_hd__xnor2_2
X_2136_ net41 add_tmp\[14\] VGND VGND VPWR VPWR _0918_ sky130_fd_sc_hd__nand2_1
XFILLER_0_76_433 VPWR VGND VPWR VGND sky130_ef_sc_hd__decap_12
XFILLER_0_48_135 VGND VGND VPWR VPWR sky130_fd_sc_hd__decap_4
XFILLER_0_8_265 VGND VGND VPWR VPWR sky130_fd_sc_hd__fill_1
XFILLER_0_29_393 VPWR VGND VPWR VGND sky130_ef_sc_hd__decap_12
X_2969_ _1678_ _1694_ _0085_ _2035_ VGND VGND VPWR VPWR _0086_ sky130_fd_sc_hd__and4_1
XFILLER_0_8_298 VGND VGND VPWR VPWR sky130_fd_sc_hd__decap_8
XFILLER_0_8_82 VGND VGND VPWR VPWR sky130_fd_sc_hd__fill_2
XFILLER_0_12_260 VGND VGND VPWR VPWR sky130_fd_sc_hd__decap_6
XFILLER_0_39_113 VGND VGND VPWR VPWR sky130_fd_sc_hd__fill_2
XFILLER_0_54_116 VGND VGND VPWR VPWR sky130_fd_sc_hd__decap_4
XFILLER_0_40_29 VPWR VGND VPWR VGND sky130_ef_sc_hd__decap_12
XFILLER_0_62_193 VGND VGND VPWR VPWR sky130_fd_sc_hd__decap_3
XFILLER_0_10_208 VGND VGND VPWR VPWR sky130_fd_sc_hd__fill_1
XFILLER_0_50_344 VPWR VGND VPWR VGND sky130_ef_sc_hd__decap_12
XFILLER_0_50_399 VGND VGND VPWR VPWR sky130_fd_sc_hd__fill_1
XFILLER_0_4_29 VPWR VGND VPWR VGND sky130_ef_sc_hd__decap_12
XFILLER_0_77_219 VGND VGND VPWR VPWR sky130_fd_sc_hd__decap_4
XFILLER_0_58_433 VPWR VGND VPWR VGND sky130_ef_sc_hd__decap_12
X_3941_ _1974_ _0462_ _0327_ _0530_ VGND VGND VPWR VPWR _1069_ sky130_fd_sc_hd__nand4_1
XFILLER_0_14_85 VPWR VGND VPWR VGND sky130_ef_sc_hd__decap_12
X_3872_ _0937_ _0939_ _0941_ VGND VGND VPWR VPWR _0995_ sky130_fd_sc_hd__or3_1
XFILLER_0_5_202 VGND VGND VPWR VPWR sky130_fd_sc_hd__fill_1
X_2823_ _1697_ _1727_ _1797_ _1816_ VGND VGND VPWR VPWR _1999_ sky130_fd_sc_hd__and4_1
XFILLER_0_73_447 VGND VGND VPWR VPWR sky130_fd_sc_hd__fill_1
XFILLER_0_41_300 VPWR VGND VPWR VGND sky130_ef_sc_hd__decap_12
X_2754_ _1755_ _1744_ _1774_ _1782_ VGND VGND VPWR VPWR _1931_ sky130_fd_sc_hd__a22o_1
XFILLER_0_53_160 VGND VGND VPWR VPWR sky130_fd_sc_hd__decap_4
XFILLER_0_26_385 VGND VGND VPWR VPWR sky130_fd_sc_hd__decap_3
X_2685_ _1813_ _1862_ _1675_ VGND VGND VPWR VPWR _1864_ sky130_fd_sc_hd__a21o_1
XFILLER_0_1_441 VGND VGND VPWR VPWR sky130_fd_sc_hd__decap_6
XTAP_241 VGND VPWR sky130_fd_sc_hd__tapvpwrvgnd_1
XTAP_230 VGND VPWR sky130_fd_sc_hd__tapvpwrvgnd_1
XFILLER_0_39_93 VPWR VGND VPWR VGND sky130_ef_sc_hd__decap_12
X_3306_ _0321_ _0418_ _0419_ VGND VGND VPWR VPWR _0053_ sky130_fd_sc_hd__o21ai_1
XTAP_274 VGND VPWR sky130_fd_sc_hd__tapvpwrvgnd_1
X_4286_ clknet_3_0__leaf_clk _0031_ net35 VGND VGND VPWR VPWR net57 sky130_fd_sc_hd__dfrtp_4
XTAP_263 VGND VPWR sky130_fd_sc_hd__tapvpwrvgnd_1
XTAP_252 VGND VPWR sky130_fd_sc_hd__tapvpwrvgnd_1
XTAP_296 VGND VPWR sky130_fd_sc_hd__tapvpwrvgnd_1
XTAP_285 VGND VPWR sky130_fd_sc_hd__tapvpwrvgnd_1
X_3237_ _0347_ _0348_ _0349_ VGND VGND VPWR VPWR _0351_ sky130_fd_sc_hd__a21o_1
X_3168_ _0281_ _0282_ VGND VGND VPWR VPWR _0283_ sky130_fd_sc_hd__nor2_2
XFILLER_0_55_92 VGND VGND VPWR VPWR sky130_fd_sc_hd__fill_2
X_3099_ _0206_ _0214_ VGND VGND VPWR VPWR _0215_ sky130_fd_sc_hd__xor2_1
XFILLER_0_64_414 VGND VGND VPWR VPWR sky130_fd_sc_hd__fill_1
XFILLER_0_76_296 VPWR VGND VPWR VGND sky130_ef_sc_hd__decap_12
XFILLER_0_32_300 VGND VGND VPWR VPWR sky130_fd_sc_hd__decap_8
XFILLER_0_44_193 VGND VGND VPWR VPWR sky130_fd_sc_hd__decap_3
XFILLER_0_67_241 VGND VGND VPWR VPWR sky130_fd_sc_hd__decap_3
XFILLER_0_51_28 VPWR VGND VPWR VGND sky130_ef_sc_hd__decap_12
XFILLER_0_35_160 VGND VGND VPWR VPWR sky130_fd_sc_hd__decap_8
XFILLER_0_50_141 VGND VGND VPWR VPWR sky130_fd_sc_hd__decap_4
X_2470_ _1655_ VGND VGND VPWR VPWR _1656_ sky130_fd_sc_hd__clkbuf_2
XFILLER_0_50_185 VGND VGND VPWR VPWR sky130_fd_sc_hd__fill_1
XFILLER_0_76_25 VGND VGND VPWR VPWR sky130_fd_sc_hd__decap_3
X_4140_ _1241_ _1283_ _1236_ VGND VGND VPWR VPWR _1284_ sky130_fd_sc_hd__o21ai_1
X_4071_ _1128_ _1151_ _1209_ VGND VGND VPWR VPWR _1210_ sky130_fd_sc_hd__a21o_1
X_3022_ _0136_ _0137_ net83 _0075_ VGND VGND VPWR VPWR _0139_ sky130_fd_sc_hd__o211a_1
X_3924_ _0981_ _0986_ _1051_ VGND VGND VPWR VPWR _1052_ sky130_fd_sc_hd__o21ai_1
XFILLER_0_73_211 VGND VGND VPWR VPWR sky130_fd_sc_hd__decap_3
XFILLER_0_41_50 VGND VGND VPWR VPWR sky130_fd_sc_hd__decap_3
XFILLER_0_73_233 VPWR VGND VPWR VGND sky130_ef_sc_hd__decap_12
X_3855_ _0975_ _0972_ _0974_ VGND VGND VPWR VPWR _0977_ sky130_fd_sc_hd__nand3_2
X_2806_ _1913_ _1914_ _1916_ VGND VGND VPWR VPWR _1983_ sky130_fd_sc_hd__and3_1
X_3786_ _0899_ _0901_ VGND VGND VPWR VPWR _0902_ sky130_fd_sc_hd__xor2_1
XFILLER_0_73_288 VPWR VGND VPWR VGND sky130_ef_sc_hd__decap_12
X_2737_ _1794_ _1854_ _1852_ _1853_ VGND VGND VPWR VPWR _1915_ sky130_fd_sc_hd__o211a_1
X_2668_ _1835_ _1836_ _1846_ VGND VGND VPWR VPWR _1847_ sky130_fd_sc_hd__nand3_1
XFILLER_0_74_3 VPWR VGND VPWR VGND sky130_ef_sc_hd__decap_12
X_2599_ _1746_ _1743_ _1745_ VGND VGND VPWR VPWR _1779_ sky130_fd_sc_hd__a21bo_1
X_4269_ clknet_3_5__leaf_clk _0014_ net35 VGND VGND VPWR VPWR net39 sky130_fd_sc_hd__dfrtp_2
XFILLER_0_66_80 VGND VGND VPWR VPWR sky130_fd_sc_hd__decap_4
XFILLER_0_9_393 VGND VGND VPWR VPWR sky130_fd_sc_hd__fill_1
XFILLER_0_64_277 VGND VGND VPWR VPWR sky130_fd_sc_hd__fill_1
XFILLER_0_17_160 VGND VGND VPWR VPWR sky130_fd_sc_hd__fill_1
XFILLER_0_24_119 VGND VGND VPWR VPWR sky130_fd_sc_hd__decap_3
XFILLER_0_32_141 VGND VGND VPWR VPWR sky130_fd_sc_hd__decap_8
XFILLER_0_32_163 VGND VGND VPWR VPWR sky130_fd_sc_hd__decap_3
XFILLER_0_20_325 VGND VGND VPWR VPWR sky130_fd_sc_hd__fill_1
XFILLER_0_20_358 VGND VGND VPWR VPWR sky130_fd_sc_hd__decap_6
XFILLER_0_62_27 VGND VGND VPWR VPWR sky130_fd_sc_hd__fill_1
XFILLER_0_62_49 VGND VGND VPWR VPWR sky130_fd_sc_hd__fill_2
XFILLER_0_28_414 VGND VGND VPWR VPWR sky130_fd_sc_hd__decap_6
XFILLER_0_15_119 VGND VGND VPWR VPWR sky130_fd_sc_hd__fill_1
X_3640_ _0289_ _0746_ _0689_ _0748_ _0688_ VGND VGND VPWR VPWR _0749_ sky130_fd_sc_hd__a311oi_2
XFILLER_0_43_439 VGND VGND VPWR VPWR sky130_fd_sc_hd__decap_8
X_3571_ _1973_ _0354_ _0083_ _0112_ VGND VGND VPWR VPWR _0681_ sky130_fd_sc_hd__a22o_1
XFILLER_0_70_269 VPWR VGND VPWR VGND sky130_ef_sc_hd__decap_12
X_2522_ _1703_ _1704_ VGND VGND VPWR VPWR _1705_ sky130_fd_sc_hd__xnor2_1
XFILLER_0_51_461 VGND VGND VPWR VPWR sky130_fd_sc_hd__fill_2
X_2453_ _1642_ VGND VGND VPWR VPWR _0034_ sky130_fd_sc_hd__clkbuf_1
X_2384_ _1432_ _1416_ _1419_ VGND VGND VPWR VPWR _1586_ sky130_fd_sc_hd__and3_1
X_4123_ _1205_ _1218_ _1206_ VGND VGND VPWR VPWR _1267_ sky130_fd_sc_hd__o21ai_2
X_4054_ _1190_ _1191_ VGND VGND VPWR VPWR _1192_ sky130_fd_sc_hd__xnor2_1
Xinput2 en VGND VGND VPWR VPWR net2 sky130_fd_sc_hd__dlymetal6s2s_1
X_3005_ _0116_ _0119_ _0121_ VGND VGND VPWR VPWR _0122_ sky130_fd_sc_hd__nand3_1
XFILLER_0_36_83 VGND VGND VPWR VPWR sky130_fd_sc_hd__fill_1
XFILLER_0_52_71 VGND VGND VPWR VPWR sky130_fd_sc_hd__fill_1
X_3907_ _0928_ _0933_ VGND VGND VPWR VPWR _1033_ sky130_fd_sc_hd__nand2_1
XFILLER_0_34_417 VGND VGND VPWR VPWR sky130_fd_sc_hd__decap_3
X_3838_ _0880_ _0883_ _0956_ _0957_ VGND VGND VPWR VPWR _0958_ sky130_fd_sc_hd__o211a_2
XFILLER_0_6_396 VGND VGND VPWR VPWR sky130_fd_sc_hd__fill_1
XFILLER_0_6_363 VGND VGND VPWR VPWR sky130_fd_sc_hd__fill_1
X_3769_ _0852_ _0854_ _0880_ _0881_ VGND VGND VPWR VPWR _0883_ sky130_fd_sc_hd__nor4_4
XFILLER_0_10_380 VGND VGND VPWR VPWR sky130_fd_sc_hd__fill_1
XFILLER_0_69_358 VGND VGND VPWR VPWR sky130_fd_sc_hd__decap_4
XFILLER_0_77_391 VGND VGND VPWR VPWR sky130_fd_sc_hd__fill_1
XFILLER_0_37_244 VGND VGND VPWR VPWR sky130_fd_sc_hd__decap_8
XFILLER_0_37_288 VPWR VGND VPWR VGND sky130_ef_sc_hd__decap_12
XFILLER_0_52_203 VPWR VGND VPWR VGND sky130_ef_sc_hd__decap_12
XFILLER_0_33_461 VGND VGND VPWR VPWR sky130_fd_sc_hd__fill_2
XFILLER_0_20_122 VGND VGND VPWR VPWR sky130_fd_sc_hd__decap_6
XFILLER_0_20_133 VGND VGND VPWR VPWR sky130_fd_sc_hd__decap_6
XFILLER_0_73_15 VPWR VGND VPWR VGND sky130_ef_sc_hd__decap_12
XFILLER_0_22_52 VPWR VGND VPWR VGND sky130_ef_sc_hd__decap_12
XFILLER_0_7_149 VGND VGND VPWR VPWR sky130_fd_sc_hd__decap_8
XFILLER_0_22_85 VGND VGND VPWR VPWR sky130_fd_sc_hd__fill_2
XFILLER_0_28_299 VGND VGND VPWR VPWR sky130_fd_sc_hd__decap_8
XFILLER_0_43_225 VGND VGND VPWR VPWR sky130_fd_sc_hd__decap_4
X_3623_ _0668_ _0669_ _0732_ VGND VGND VPWR VPWR _0733_ sky130_fd_sc_hd__a21o_1
XFILLER_0_43_247 VPWR VGND VPWR VGND sky130_ef_sc_hd__decap_12
XFILLER_0_3_388 VGND VGND VPWR VPWR sky130_fd_sc_hd__decap_4
X_3554_ _0507_ _0512_ _0593_ _0664_ VGND VGND VPWR VPWR _0665_ sky130_fd_sc_hd__o31a_1
X_2505_ _1684_ _1688_ VGND VGND VPWR VPWR _1689_ sky130_fd_sc_hd__xnor2_1
X_3485_ add_tmp\[17\] _0595_ _0596_ VGND VGND VPWR VPWR _0597_ sky130_fd_sc_hd__mux2_1
X_2436_ _1620_ _1458_ _1464_ _1471_ VGND VGND VPWR VPWR _1628_ sky130_fd_sc_hd__o211a_1
XFILLER_0_11_188 VGND VGND VPWR VPWR sky130_fd_sc_hd__fill_1
XFILLER_0_37_3 VGND VGND VPWR VPWR sky130_fd_sc_hd__decap_4
X_2367_ _0875_ _1571_ VGND VGND VPWR VPWR _1572_ sky130_fd_sc_hd__nand2_1
X_4106_ _1246_ _1247_ VGND VGND VPWR VPWR _1248_ sky130_fd_sc_hd__or2_1
X_2298_ clr_delay VGND VGND VPWR VPWR _1516_ sky130_fd_sc_hd__clkbuf_2
X_4037_ _1121_ _1122_ _1172_ _1173_ VGND VGND VPWR VPWR _1174_ sky130_fd_sc_hd__o211a_1
XPHY_106 VGND VGND VPWR VPWR sky130_fd_sc_hd__decap_3
XFILLER_0_63_81 VGND VGND VPWR VPWR sky130_fd_sc_hd__fill_1
XPHY_117 VGND VGND VPWR VPWR sky130_fd_sc_hd__decap_3
XPHY_128 VGND VGND VPWR VPWR sky130_fd_sc_hd__decap_3
XPHY_139 VGND VGND VPWR VPWR sky130_fd_sc_hd__decap_3
XFILLER_0_15_461 VGND VGND VPWR VPWR sky130_fd_sc_hd__fill_2
XFILLER_0_34_269 VGND VGND VPWR VPWR sky130_fd_sc_hd__decap_3
XFILLER_0_43_18 VPWR VGND VPWR VGND sky130_ef_sc_hd__decap_12
XPHY_8 VGND VGND VPWR VPWR sky130_fd_sc_hd__decap_3
XFILLER_0_72_309 VPWR VGND VPWR VGND sky130_ef_sc_hd__decap_12
XFILLER_0_68_15 VPWR VGND VPWR VGND sky130_ef_sc_hd__decap_12
X_3270_ _0380_ _0383_ VGND VGND VPWR VPWR _0384_ sky130_fd_sc_hd__xor2_4
XTAP_604 VGND VPWR sky130_fd_sc_hd__tapvpwrvgnd_1
XTAP_615 VGND VPWR sky130_fd_sc_hd__tapvpwrvgnd_1
X_2221_ net54 add_tmp\[26\] VGND VGND VPWR VPWR _1445_ sky130_fd_sc_hd__or2_1
XTAP_626 VGND VPWR sky130_fd_sc_hd__tapvpwrvgnd_1
XTAP_637 VGND VPWR sky130_fd_sc_hd__tapvpwrvgnd_1
XTAP_648 VGND VPWR sky130_fd_sc_hd__tapvpwrvgnd_1
XTAP_659 VGND VPWR sky130_fd_sc_hd__tapvpwrvgnd_1
XFILLER_0_17_41 VGND VGND VPWR VPWR sky130_fd_sc_hd__decap_8
X_2152_ net65 add_tmp\[3\] VGND VGND VPWR VPWR _1092_ sky130_fd_sc_hd__nor2_1
XFILLER_0_17_52 VGND VGND VPWR VPWR sky130_fd_sc_hd__decap_4
XFILLER_0_75_158 VGND VGND VPWR VPWR sky130_fd_sc_hd__fill_2
X_2985_ _1829_ _1900_ _2075_ _1825_ VGND VGND VPWR VPWR _0102_ sky130_fd_sc_hd__a22o_1
XFILLER_0_16_225 VGND VGND VPWR VPWR sky130_fd_sc_hd__fill_1
XFILLER_0_31_239 VGND VGND VPWR VPWR sky130_fd_sc_hd__fill_1
X_3606_ _0712_ _0713_ _0714_ VGND VGND VPWR VPWR _0716_ sky130_fd_sc_hd__a21oi_1
X_3537_ _0644_ _0647_ VGND VGND VPWR VPWR _0648_ sky130_fd_sc_hd__xor2_2
XFILLER_0_58_81 VGND VGND VPWR VPWR sky130_fd_sc_hd__decap_3
X_3468_ _0559_ _0579_ VGND VGND VPWR VPWR _0580_ sky130_fd_sc_hd__xnor2_1
X_2419_ net54 _1614_ _1597_ VGND VGND VPWR VPWR _1615_ sky130_fd_sc_hd__mux2_1
X_3399_ _0508_ _0317_ _0417_ _0510_ _0511_ VGND VGND VPWR VPWR _0512_ sky130_fd_sc_hd__o311a_4
XFILLER_0_54_309 VPWR VGND VPWR VGND sky130_ef_sc_hd__decap_12
XFILLER_0_66_158 VGND VGND VPWR VPWR sky130_fd_sc_hd__decap_3
XFILLER_0_57_125 VGND VGND VPWR VPWR sky130_fd_sc_hd__fill_1
XFILLER_0_70_27 VGND VGND VPWR VPWR sky130_fd_sc_hd__fill_1
XFILLER_0_38_361 VGND VGND VPWR VPWR sky130_fd_sc_hd__decap_3
XFILLER_0_5_406 VPWR VGND VPWR VGND sky130_ef_sc_hd__decap_12
XFILLER_0_38_394 VPWR VGND VPWR VGND sky130_ef_sc_hd__decap_12
X_2770_ _1944_ _1945_ _1946_ VGND VGND VPWR VPWR _1947_ sky130_fd_sc_hd__nand3_1
XFILLER_0_0_111 VGND VGND VPWR VPWR sky130_fd_sc_hd__fill_1
XFILLER_0_21_250 VPWR VGND VPWR VGND sky130_ef_sc_hd__decap_12
XTAP_401 VGND VPWR sky130_fd_sc_hd__tapvpwrvgnd_1
XTAP_412 VGND VPWR sky130_fd_sc_hd__tapvpwrvgnd_1
XTAP_423 VGND VPWR sky130_fd_sc_hd__tapvpwrvgnd_1
X_3322_ _1841_ _0270_ _0183_ _1881_ VGND VGND VPWR VPWR _0435_ sky130_fd_sc_hd__a22o_1
XTAP_434 VGND VPWR sky130_fd_sc_hd__tapvpwrvgnd_1
XTAP_445 VGND VPWR sky130_fd_sc_hd__tapvpwrvgnd_1
XTAP_456 VGND VPWR sky130_fd_sc_hd__tapvpwrvgnd_1
XTAP_467 VGND VPWR sky130_fd_sc_hd__tapvpwrvgnd_1
X_3253_ _0292_ _0298_ net125 VGND VGND VPWR VPWR _0367_ sky130_fd_sc_hd__a21o_1
XTAP_478 VGND VPWR sky130_fd_sc_hd__tapvpwrvgnd_1
XTAP_489 VGND VPWR sky130_fd_sc_hd__tapvpwrvgnd_1
X_3184_ _0297_ _0298_ VGND VGND VPWR VPWR _0299_ sky130_fd_sc_hd__or2b_4
X_2204_ _1423_ _1424_ _1427_ VGND VGND VPWR VPWR _1428_ sky130_fd_sc_hd__and3_1
X_2135_ net42 add_tmp\[15\] VGND VGND VPWR VPWR _0908_ sky130_fd_sc_hd__nor2_1
XFILLER_0_76_445 VPWR VGND VPWR VGND sky130_ef_sc_hd__decap_12
XFILLER_0_36_309 VGND VGND VPWR VPWR sky130_fd_sc_hd__decap_8
X_2968_ net34 VGND VGND VPWR VPWR _0085_ sky130_fd_sc_hd__buf_4
XFILLER_0_44_342 VPWR VGND VPWR VGND sky130_ef_sc_hd__decap_12
XFILLER_0_56_191 VGND VGND VPWR VPWR sky130_fd_sc_hd__decap_4
XFILLER_0_60_60 VPWR VGND VPWR VGND sky130_ef_sc_hd__decap_12
X_2899_ _2006_ _1787_ _2012_ _2011_ VGND VGND VPWR VPWR _2074_ sky130_fd_sc_hd__a31o_1
XFILLER_0_69_91 VGND VGND VPWR VPWR sky130_fd_sc_hd__decap_3
XFILLER_0_39_169 VGND VGND VPWR VPWR sky130_fd_sc_hd__decap_6
XFILLER_0_54_139 VGND VGND VPWR VPWR sky130_fd_sc_hd__fill_1
XFILLER_0_35_386 VGND VGND VPWR VPWR sky130_fd_sc_hd__decap_6
XFILLER_0_50_356 VGND VGND VPWR VPWR sky130_fd_sc_hd__decap_8
XFILLER_0_77_209 VGND VGND VPWR VPWR sky130_fd_sc_hd__decap_4
X_3940_ _0462_ _0536_ _0859_ _0369_ VGND VGND VPWR VPWR _1068_ sky130_fd_sc_hd__a22o_1
XFILLER_0_14_53 VGND VGND VPWR VPWR sky130_fd_sc_hd__fill_1
XFILLER_0_58_445 VPWR VGND VPWR VGND sky130_ef_sc_hd__decap_12
XFILLER_0_18_309 VPWR VGND VPWR VGND sky130_ef_sc_hd__decap_12
X_3871_ _0449_ _0530_ _0934_ _0935_ VGND VGND VPWR VPWR _0993_ sky130_fd_sc_hd__a22o_1
XFILLER_0_14_97 VPWR VGND VPWR VGND sky130_ef_sc_hd__decap_12
X_2822_ _1997_ _1930_ _1932_ _1928_ VGND VGND VPWR VPWR _1998_ sky130_fd_sc_hd__o2bb2a_4
XFILLER_0_5_236 VPWR VGND VPWR VGND sky130_ef_sc_hd__decap_12
XFILLER_0_5_225 VGND VGND VPWR VPWR sky130_fd_sc_hd__decap_4
XFILLER_0_30_41 VGND VGND VPWR VPWR sky130_fd_sc_hd__decap_8
X_2753_ _1782_ _1715_ _1744_ VGND VGND VPWR VPWR _1930_ sky130_fd_sc_hd__and3_1
XFILLER_0_41_312 VGND VGND VPWR VPWR sky130_fd_sc_hd__decap_4
X_2684_ _1813_ _1862_ VGND VGND VPWR VPWR _1863_ sky130_fd_sc_hd__nor2_4
XFILLER_0_53_194 VGND VGND VPWR VPWR sky130_fd_sc_hd__decap_8
XFILLER_0_41_389 VGND VGND VPWR VPWR sky130_fd_sc_hd__decap_3
XTAP_242 VGND VPWR sky130_fd_sc_hd__tapvpwrvgnd_1
XTAP_231 VGND VPWR sky130_fd_sc_hd__tapvpwrvgnd_1
XTAP_220 VGND VPWR sky130_fd_sc_hd__tapvpwrvgnd_1
X_3305_ net133 _0321_ VGND VGND VPWR VPWR _0419_ sky130_fd_sc_hd__nand2_1
X_4285_ clknet_3_1__leaf_clk _0030_ net35 VGND VGND VPWR VPWR net56 sky130_fd_sc_hd__dfrtp_4
XTAP_275 VGND VPWR sky130_fd_sc_hd__tapvpwrvgnd_1
XTAP_264 VGND VPWR sky130_fd_sc_hd__tapvpwrvgnd_1
XTAP_253 VGND VPWR sky130_fd_sc_hd__tapvpwrvgnd_1
XTAP_297 VGND VPWR sky130_fd_sc_hd__tapvpwrvgnd_1
XTAP_286 VGND VPWR sky130_fd_sc_hd__tapvpwrvgnd_1
X_3236_ _0347_ _0348_ _0349_ VGND VGND VPWR VPWR _0350_ sky130_fd_sc_hd__nand3_2
X_3167_ _0279_ _0280_ _1837_ _0277_ VGND VGND VPWR VPWR _0282_ sky130_fd_sc_hd__and4bb_1
X_3098_ _0207_ _0213_ VGND VGND VPWR VPWR _0214_ sky130_fd_sc_hd__xnor2_1
XFILLER_0_67_231 VGND VGND VPWR VPWR sky130_fd_sc_hd__fill_1
XFILLER_0_67_297 VGND VGND VPWR VPWR sky130_fd_sc_hd__decap_3
XFILLER_0_23_301 VGND VGND VPWR VPWR sky130_fd_sc_hd__decap_8
XFILLER_0_23_345 VGND VGND VPWR VPWR sky130_fd_sc_hd__fill_1
XFILLER_0_50_175 VGND VGND VPWR VPWR sky130_fd_sc_hd__decap_3
X_4070_ _1130_ _1150_ VGND VGND VPWR VPWR _1209_ sky130_fd_sc_hd__and2_1
X_3021_ net83 _0075_ _0136_ net102 VGND VGND VPWR VPWR _0138_ sky130_fd_sc_hd__a211oi_2
XFILLER_0_25_63 VGND VGND VPWR VPWR sky130_fd_sc_hd__decap_4
XFILLER_0_25_96 VPWR VGND VPWR VGND sky130_ef_sc_hd__decap_12
XFILLER_0_58_253 VGND VGND VPWR VPWR sky130_fd_sc_hd__fill_2
X_3923_ _0978_ _0980_ VGND VGND VPWR VPWR _1051_ sky130_fd_sc_hd__or2_1
X_3854_ _0972_ _0974_ _0975_ VGND VGND VPWR VPWR _0976_ sky130_fd_sc_hd__a21o_1
XFILLER_0_73_245 VGND VGND VPWR VPWR sky130_fd_sc_hd__decap_4
XFILLER_0_33_109 VGND VGND VPWR VPWR sky130_fd_sc_hd__decap_3
XFILLER_0_41_84 VGND VGND VPWR VPWR sky130_fd_sc_hd__decap_6
X_2805_ _1980_ _1981_ VGND VGND VPWR VPWR _1982_ sky130_fd_sc_hd__xnor2_2
XFILLER_0_61_418 VPWR VGND VPWR VGND sky130_ef_sc_hd__decap_12
X_3785_ _0752_ _0804_ _0900_ VGND VGND VPWR VPWR _0901_ sky130_fd_sc_hd__o21ai_1
X_2736_ _1912_ _1910_ _1911_ VGND VGND VPWR VPWR _1914_ sky130_fd_sc_hd__or3_4
X_2667_ _1838_ _1845_ VGND VGND VPWR VPWR _1846_ sky130_fd_sc_hd__xnor2_2
XFILLER_0_67_3 VPWR VGND VPWR VGND sky130_ef_sc_hd__decap_12
X_2598_ _1776_ _1773_ _1775_ VGND VGND VPWR VPWR _1778_ sky130_fd_sc_hd__nand3_1
X_4268_ clknet_3_7__leaf_clk _0013_ net35 VGND VGND VPWR VPWR net38 sky130_fd_sc_hd__dfrtp_2
X_3219_ _1658_ _0332_ _0329_ VGND VGND VPWR VPWR _0333_ sky130_fd_sc_hd__nand3_1
X_4199_ _0869_ _1290_ _1346_ _1347_ VGND VGND VPWR VPWR _1348_ sky130_fd_sc_hd__a22o_1
XFILLER_0_49_231 VPWR VGND VPWR VGND sky130_ef_sc_hd__decap_12
XFILLER_0_20_304 VGND VGND VPWR VPWR sky130_fd_sc_hd__decap_4
XFILLER_0_46_29 VGND VGND VPWR VPWR sky130_fd_sc_hd__fill_1
XFILLER_0_55_223 VGND VGND VPWR VPWR sky130_fd_sc_hd__fill_1
XFILLER_0_15_109 VGND VGND VPWR VPWR sky130_fd_sc_hd__decap_3
XFILLER_0_55_245 VPWR VGND VPWR VGND sky130_ef_sc_hd__decap_12
XFILLER_0_11_32 VPWR VGND VPWR VGND sky130_ef_sc_hd__decap_12
XFILLER_0_11_21 VGND VGND VPWR VPWR sky130_fd_sc_hd__fill_1
X_3570_ _0611_ VGND VGND VPWR VPWR _0680_ sky130_fd_sc_hd__inv_2
XFILLER_0_51_440 VGND VGND VPWR VPWR sky130_fd_sc_hd__decap_8
XFILLER_0_70_248 VGND VGND VPWR VPWR sky130_fd_sc_hd__decap_4
XFILLER_0_11_304 VPWR VGND VPWR VGND sky130_ef_sc_hd__decap_12
XFILLER_0_23_153 VPWR VGND VPWR VGND sky130_ef_sc_hd__decap_12
X_2521_ _1682_ _1688_ _1683_ VGND VGND VPWR VPWR _1704_ sky130_fd_sc_hd__o21ba_1
XFILLER_0_11_337 VPWR VGND VPWR VGND sky130_ef_sc_hd__decap_12
X_2452_ net61 _1641_ _1636_ VGND VGND VPWR VPWR _1642_ sky130_fd_sc_hd__mux2_1
XFILLER_0_53_9 VGND VGND VPWR VPWR sky130_fd_sc_hd__fill_1
X_2383_ _1416_ _1419_ _1432_ VGND VGND VPWR VPWR _1585_ sky130_fd_sc_hd__a21oi_1
X_4122_ _1253_ _1264_ VGND VGND VPWR VPWR _1266_ sky130_fd_sc_hd__xnor2_1
X_4053_ _1131_ _0398_ VGND VGND VPWR VPWR _1191_ sky130_fd_sc_hd__nand2_1
X_3004_ _1693_ _2096_ _0120_ _1695_ VGND VGND VPWR VPWR _0121_ sky130_fd_sc_hd__a22o_1
Xinput3 in_a[0] VGND VGND VPWR VPWR net3 sky130_fd_sc_hd__clkbuf_2
XFILLER_0_19_415 VGND VGND VPWR VPWR sky130_fd_sc_hd__fill_1
X_3906_ _1029_ _1030_ _0991_ _0992_ VGND VGND VPWR VPWR _1032_ sky130_fd_sc_hd__a211oi_1
XFILLER_0_52_83 VGND VGND VPWR VPWR sky130_fd_sc_hd__fill_1
X_3837_ _0932_ _0933_ _0954_ _0955_ VGND VGND VPWR VPWR _0957_ sky130_fd_sc_hd__nand4_1
XFILLER_0_46_289 VGND VGND VPWR VPWR sky130_fd_sc_hd__decap_3
X_3768_ _0852_ _0854_ _0880_ _0881_ VGND VGND VPWR VPWR _0882_ sky130_fd_sc_hd__o22a_1
XFILLER_0_42_440 VGND VGND VPWR VPWR sky130_fd_sc_hd__decap_3
XFILLER_0_14_153 VGND VGND VPWR VPWR sky130_fd_sc_hd__decap_3
X_2719_ _1797_ VGND VGND VPWR VPWR _1897_ sky130_fd_sc_hd__buf_6
XFILLER_0_14_197 VPWR VGND VPWR VGND sky130_ef_sc_hd__decap_12
X_3699_ _0805_ _0807_ VGND VGND VPWR VPWR _0808_ sky130_fd_sc_hd__xnor2_1
XFILLER_0_37_256 VPWR VGND VPWR VGND sky130_ef_sc_hd__decap_12
XFILLER_0_37_278 VGND VGND VPWR VPWR sky130_fd_sc_hd__fill_2
XFILLER_0_52_215 VGND VGND VPWR VPWR sky130_fd_sc_hd__decap_8
XFILLER_0_57_39 VGND VGND VPWR VPWR sky130_fd_sc_hd__fill_1
XFILLER_0_73_27 VPWR VGND VPWR VGND sky130_ef_sc_hd__decap_12
XFILLER_0_16_407 VGND VGND VPWR VPWR sky130_fd_sc_hd__decap_8
XFILLER_0_28_234 VPWR VGND VPWR VGND sky130_ef_sc_hd__decap_12
XFILLER_0_22_64 VGND VGND VPWR VPWR sky130_fd_sc_hd__decap_3
XFILLER_0_43_259 VPWR VGND VPWR VGND sky130_ef_sc_hd__decap_12
X_3622_ _0670_ _0731_ VGND VGND VPWR VPWR _0732_ sky130_fd_sc_hd__xnor2_1
X_3553_ _0505_ _0591_ _0592_ VGND VGND VPWR VPWR _0664_ sky130_fd_sc_hd__o21bai_1
X_2504_ _1662_ _1687_ VGND VGND VPWR VPWR _1688_ sky130_fd_sc_hd__nand2_1
X_3484_ _1489_ VGND VGND VPWR VPWR _0596_ sky130_fd_sc_hd__clkbuf_2
X_2435_ _1467_ _1620_ _1457_ _1464_ _1456_ VGND VGND VPWR VPWR _1627_ sky130_fd_sc_hd__a311o_1
X_4105_ _1234_ _1236_ _1245_ VGND VGND VPWR VPWR _1247_ sky130_fd_sc_hd__a21oi_1
X_2366_ _0897_ _0908_ _1393_ VGND VGND VPWR VPWR _1571_ sky130_fd_sc_hd__or3_1
X_2297_ _1200_ _1081_ _1189_ VGND VGND VPWR VPWR _1515_ sky130_fd_sc_hd__a21o_1
X_4036_ _1169_ _1170_ _1101_ _1123_ VGND VGND VPWR VPWR _1173_ sky130_fd_sc_hd__o211ai_1
XFILLER_0_2_41 VPWR VGND VPWR VGND sky130_ef_sc_hd__decap_12
XPHY_107 VGND VGND VPWR VPWR sky130_fd_sc_hd__decap_3
XPHY_118 VGND VGND VPWR VPWR sky130_fd_sc_hd__decap_3
XFILLER_0_59_370 VGND VGND VPWR VPWR sky130_fd_sc_hd__fill_1
XPHY_129 VGND VGND VPWR VPWR sky130_fd_sc_hd__decap_3
XFILLER_0_74_362 VGND VGND VPWR VPWR sky130_fd_sc_hd__fill_2
XFILLER_0_19_289 VGND VGND VPWR VPWR sky130_fd_sc_hd__fill_1
XFILLER_0_6_194 VGND VGND VPWR VPWR sky130_fd_sc_hd__fill_2
XFILLER_0_30_421 VPWR VGND VPWR VGND sky130_ef_sc_hd__decap_12
XPHY_9 VGND VGND VPWR VPWR sky130_fd_sc_hd__decap_3
XFILLER_0_57_329 VGND VGND VPWR VPWR sky130_fd_sc_hd__fill_2
XFILLER_0_69_189 VGND VGND VPWR VPWR sky130_fd_sc_hd__decap_4
XFILLER_0_33_281 VPWR VGND VPWR VGND sky130_ef_sc_hd__decap_12
XFILLER_0_0_315 VPWR VGND VPWR VGND sky130_ef_sc_hd__decap_12
XFILLER_0_68_27 VGND VGND VPWR VPWR sky130_fd_sc_hd__fill_1
XFILLER_0_0_348 VGND VGND VPWR VPWR sky130_fd_sc_hd__decap_4
XTAP_605 VGND VPWR sky130_fd_sc_hd__tapvpwrvgnd_1
XTAP_616 VGND VPWR sky130_fd_sc_hd__tapvpwrvgnd_1
X_2220_ net54 add_tmp\[26\] VGND VGND VPWR VPWR _1444_ sky130_fd_sc_hd__nand2_1
XTAP_627 VGND VPWR sky130_fd_sc_hd__tapvpwrvgnd_1
XTAP_638 VGND VPWR sky130_fd_sc_hd__tapvpwrvgnd_1
XTAP_649 VGND VPWR sky130_fd_sc_hd__tapvpwrvgnd_1
X_2151_ net66 add_tmp\[4\] VGND VGND VPWR VPWR _1081_ sky130_fd_sc_hd__or2_1
XFILLER_0_17_64 VGND VGND VPWR VPWR sky130_fd_sc_hd__decap_8
XFILLER_0_48_329 VGND VGND VPWR VPWR sky130_fd_sc_hd__decap_6
XFILLER_0_33_85 VPWR VGND VPWR VGND sky130_ef_sc_hd__decap_12
X_2984_ _1825_ _1774_ _2075_ VGND VGND VPWR VPWR _0101_ sky130_fd_sc_hd__and3_1
XFILLER_0_56_373 VGND VGND VPWR VPWR sky130_fd_sc_hd__decap_6
XFILLER_0_12_421 VPWR VGND VPWR VGND sky130_ef_sc_hd__decap_12
XFILLER_0_12_410 VGND VGND VPWR VPWR sky130_fd_sc_hd__decap_8
XFILLER_0_24_270 VPWR VGND VPWR VGND sky130_ef_sc_hd__decap_12
X_3605_ _0712_ _0713_ _0714_ VGND VGND VPWR VPWR _0715_ sky130_fd_sc_hd__and3_1
X_3536_ _0646_ VGND VGND VPWR VPWR _0647_ sky130_fd_sc_hd__clkbuf_2
X_3467_ _0577_ _0578_ VGND VGND VPWR VPWR _0579_ sky130_fd_sc_hd__nor2_1
X_2418_ _1514_ add_tmp\[26\] _1611_ _1613_ VGND VGND VPWR VPWR _1614_ sky130_fd_sc_hd__a22o_1
XFILLER_0_58_93 VPWR VGND VPWR VGND sky130_ef_sc_hd__decap_12
X_3398_ _0415_ _0416_ _0314_ _0316_ VGND VGND VPWR VPWR _0511_ sky130_fd_sc_hd__o211ai_1
X_2349_ _1486_ _1557_ VGND VGND VPWR VPWR _1558_ sky130_fd_sc_hd__nor2_1
X_4019_ _0952_ _1003_ _1088_ VGND VGND VPWR VPWR _1154_ sky130_fd_sc_hd__a21oi_1
XFILLER_0_15_281 VPWR VGND VPWR VGND sky130_ef_sc_hd__decap_12
XFILLER_0_30_251 VGND VGND VPWR VPWR sky130_fd_sc_hd__fill_1
XFILLER_0_54_29 VPWR VGND VPWR VGND sky130_ef_sc_hd__decap_12
XFILLER_0_5_418 VPWR VGND VPWR VGND sky130_ef_sc_hd__decap_12
XFILLER_0_65_181 VPWR VGND VPWR VGND sky130_ef_sc_hd__decap_12
XFILLER_0_53_343 VPWR VGND VPWR VGND sky130_ef_sc_hd__decap_12
XFILLER_0_21_262 VPWR VGND VPWR VGND sky130_ef_sc_hd__decap_12
X_3321_ _1839_ _0192_ _0181_ VGND VGND VPWR VPWR _0434_ sky130_fd_sc_hd__and3_1
XFILLER_0_0_167 VGND VGND VPWR VPWR sky130_fd_sc_hd__fill_1
XTAP_402 VGND VPWR sky130_fd_sc_hd__tapvpwrvgnd_1
XTAP_413 VGND VPWR sky130_fd_sc_hd__tapvpwrvgnd_1
XTAP_424 VGND VPWR sky130_fd_sc_hd__tapvpwrvgnd_1
XTAP_435 VGND VPWR sky130_fd_sc_hd__tapvpwrvgnd_1
XTAP_446 VGND VPWR sky130_fd_sc_hd__tapvpwrvgnd_1
XTAP_457 VGND VPWR sky130_fd_sc_hd__tapvpwrvgnd_1
X_3252_ _0363_ _0364_ _0287_ _0325_ VGND VGND VPWR VPWR _0366_ sky130_fd_sc_hd__o211a_1
X_2203_ _1425_ _1426_ VGND VGND VPWR VPWR _1427_ sky130_fd_sc_hd__and2_1
XTAP_468 VGND VPWR sky130_fd_sc_hd__tapvpwrvgnd_1
XTAP_479 VGND VPWR sky130_fd_sc_hd__tapvpwrvgnd_1
X_3183_ _0295_ _0296_ net104 _0196_ VGND VGND VPWR VPWR _0298_ sky130_fd_sc_hd__a211o_1
XFILLER_0_28_85 VGND VGND VPWR VPWR sky130_fd_sc_hd__decap_4
X_2134_ _0875_ _0886_ VGND VGND VPWR VPWR _0897_ sky130_fd_sc_hd__nand2_1
XFILLER_0_48_159 VPWR VGND VPWR VGND sky130_ef_sc_hd__decap_12
XFILLER_0_29_362 VPWR VGND VPWR VGND sky130_ef_sc_hd__decap_12
X_2967_ _1842_ _1973_ _0083_ _1896_ VGND VGND VPWR VPWR _0084_ sky130_fd_sc_hd__a22oi_1
XFILLER_0_60_72 VPWR VGND VPWR VGND sky130_ef_sc_hd__decap_12
X_2898_ _1999_ _2001_ VGND VGND VPWR VPWR _2073_ sky130_fd_sc_hd__or2_1
XFILLER_0_44_354 VGND VGND VPWR VPWR sky130_fd_sc_hd__decap_8
XFILLER_0_71_151 VGND VGND VPWR VPWR sky130_fd_sc_hd__fill_1
XFILLER_0_12_273 VPWR VGND VPWR VGND sky130_ef_sc_hd__decap_12
XFILLER_0_69_81 VGND VGND VPWR VPWR sky130_fd_sc_hd__decap_6
XFILLER_0_5_9 VPWR VGND VPWR VGND sky130_ef_sc_hd__decap_12
X_3519_ _1898_ _2094_ _0270_ _2077_ VGND VGND VPWR VPWR _0630_ sky130_fd_sc_hd__a22o_1
XFILLER_0_14_21 VGND VGND VPWR VPWR sky130_fd_sc_hd__decap_6
XFILLER_0_58_457 VGND VGND VPWR VPWR sky130_fd_sc_hd__decap_6
X_3870_ _0932_ _0933_ _0954_ _0955_ VGND VGND VPWR VPWR _0992_ sky130_fd_sc_hd__and4_1
XFILLER_0_73_405 VPWR VGND VPWR VGND sky130_ef_sc_hd__decap_12
XFILLER_0_26_321 VGND VGND VPWR VPWR sky130_fd_sc_hd__fill_2
X_2821_ _1996_ VGND VGND VPWR VPWR _1997_ sky130_fd_sc_hd__clkbuf_2
XFILLER_0_73_449 VPWR VGND VPWR VGND sky130_ef_sc_hd__decap_12
XFILLER_0_26_365 VPWR VGND VPWR VGND sky130_ef_sc_hd__decap_12
X_2752_ _1829_ VGND VGND VPWR VPWR _1929_ sky130_fd_sc_hd__clkbuf_2
XFILLER_0_53_140 VGND VGND VPWR VPWR sky130_fd_sc_hd__fill_2
XFILLER_0_5_248 VGND VGND VPWR VPWR sky130_fd_sc_hd__decap_4
X_2683_ _1860_ _1861_ VGND VGND VPWR VPWR _1862_ sky130_fd_sc_hd__xnor2_1
XFILLER_0_41_335 VGND VGND VPWR VPWR sky130_fd_sc_hd__fill_1
XFILLER_0_41_346 VGND VGND VPWR VPWR sky130_fd_sc_hd__fill_2
XTAP_232 VGND VPWR sky130_fd_sc_hd__tapvpwrvgnd_1
XTAP_221 VGND VPWR sky130_fd_sc_hd__tapvpwrvgnd_1
XTAP_210 VGND VPWR sky130_fd_sc_hd__tapvpwrvgnd_1
X_4284_ clknet_3_2__leaf_clk _0029_ net35 VGND VGND VPWR VPWR net55 sky130_fd_sc_hd__dfrtp_4
X_3304_ _0323_ _0417_ VGND VGND VPWR VPWR _0418_ sky130_fd_sc_hd__xnor2_1
XTAP_265 VGND VPWR sky130_fd_sc_hd__tapvpwrvgnd_1
XTAP_254 VGND VPWR sky130_fd_sc_hd__tapvpwrvgnd_1
XTAP_243 VGND VPWR sky130_fd_sc_hd__tapvpwrvgnd_1
X_3235_ net121 _0276_ _0275_ VGND VGND VPWR VPWR _0349_ sky130_fd_sc_hd__a21bo_1
XTAP_298 VGND VPWR sky130_fd_sc_hd__tapvpwrvgnd_1
XTAP_287 VGND VPWR sky130_fd_sc_hd__tapvpwrvgnd_1
XTAP_276 VGND VPWR sky130_fd_sc_hd__tapvpwrvgnd_1
X_3166_ _1892_ _0277_ _0279_ _0280_ VGND VGND VPWR VPWR _0281_ sky130_fd_sc_hd__o2bb2a_1
X_3097_ _0209_ _0212_ VGND VGND VPWR VPWR _0213_ sky130_fd_sc_hd__xor2_1
XFILLER_0_12_3 VGND VGND VPWR VPWR sky130_fd_sc_hd__decap_6
XFILLER_0_49_446 VGND VGND VPWR VPWR sky130_fd_sc_hd__fill_2
XFILLER_0_36_107 VGND VGND VPWR VPWR sky130_fd_sc_hd__decap_8
XFILLER_0_71_71 VPWR VGND VPWR VGND sky130_ef_sc_hd__decap_12
XFILLER_0_17_310 VPWR VGND VPWR VGND sky130_ef_sc_hd__decap_12
X_3999_ _0080_ _0867_ _0160_ _1131_ VGND VGND VPWR VPWR _1132_ sky130_fd_sc_hd__a22oi_1
XFILLER_0_29_181 VPWR VGND VPWR VGND sky130_ef_sc_hd__decap_12
XFILLER_0_17_398 VGND VGND VPWR VPWR sky130_fd_sc_hd__decap_4
XFILLER_0_4_281 VGND VGND VPWR VPWR sky130_fd_sc_hd__decap_4
XFILLER_0_40_390 VGND VGND VPWR VPWR sky130_fd_sc_hd__fill_1
XFILLER_0_67_221 VGND VGND VPWR VPWR sky130_fd_sc_hd__decap_3
XFILLER_0_27_107 VGND VGND VPWR VPWR sky130_fd_sc_hd__decap_4
XFILLER_0_55_405 VGND VGND VPWR VPWR sky130_fd_sc_hd__decap_4
XFILLER_0_55_449 VGND VGND VPWR VPWR sky130_fd_sc_hd__decap_8
XFILLER_0_70_419 VGND VGND VPWR VPWR sky130_fd_sc_hd__fill_1
X_3020_ _0134_ _0135_ net98 VGND VGND VPWR VPWR _0137_ sky130_fd_sc_hd__o21a_1
XFILLER_0_58_221 VPWR VGND VPWR VGND sky130_ef_sc_hd__decap_12
XFILLER_0_58_276 VPWR VGND VPWR VGND sky130_ef_sc_hd__decap_12
X_3922_ _1047_ _1048_ VGND VGND VPWR VPWR _1050_ sky130_fd_sc_hd__or2b_1
X_3853_ _0745_ _0894_ _0893_ VGND VGND VPWR VPWR _0975_ sky130_fd_sc_hd__a21o_1
XFILLER_0_41_41 VGND VGND VPWR VPWR sky130_fd_sc_hd__fill_1
XFILLER_0_58_298 VGND VGND VPWR VPWR sky130_fd_sc_hd__decap_8
X_2804_ _1910_ _1914_ VGND VGND VPWR VPWR _1981_ sky130_fd_sc_hd__and2b_1
XFILLER_0_26_151 VGND VGND VPWR VPWR sky130_fd_sc_hd__fill_1
X_3784_ _0801_ _0803_ VGND VGND VPWR VPWR _0900_ sky130_fd_sc_hd__or2_1
XFILLER_0_73_279 VGND VGND VPWR VPWR sky130_fd_sc_hd__fill_1
X_2735_ _1910_ _1911_ _1912_ VGND VGND VPWR VPWR _1913_ sky130_fd_sc_hd__o21ai_1
X_2666_ _1843_ _1844_ VGND VGND VPWR VPWR _1845_ sky130_fd_sc_hd__nor2_2
X_2597_ _1773_ _1775_ _1776_ VGND VGND VPWR VPWR _1777_ sky130_fd_sc_hd__a21o_1
XFILLER_0_5_63 VPWR VGND VPWR VGND sky130_ef_sc_hd__decap_12
X_4267_ clknet_3_7__leaf_clk _0012_ net35 VGND VGND VPWR VPWR net37 sky130_fd_sc_hd__dfrtp_2
X_4198_ _0938_ _0744_ _1288_ VGND VGND VPWR VPWR _1347_ sky130_fd_sc_hd__a21o_1
X_3218_ _0331_ VGND VGND VPWR VPWR _0332_ sky130_fd_sc_hd__clkbuf_2
X_3149_ _0215_ _0201_ _0202_ VGND VGND VPWR VPWR _0264_ sky130_fd_sc_hd__nand3_1
XFILLER_0_49_243 VGND VGND VPWR VPWR sky130_fd_sc_hd__decap_6
XFILLER_0_37_449 VGND VGND VPWR VPWR sky130_fd_sc_hd__decap_8
XFILLER_0_64_224 VGND VGND VPWR VPWR sky130_fd_sc_hd__decap_3
XFILLER_0_17_140 VPWR VGND VPWR VGND sky130_ef_sc_hd__decap_12
XFILLER_0_62_29 VPWR VGND VPWR VGND sky130_ef_sc_hd__decap_12
XFILLER_0_55_257 VGND VGND VPWR VPWR sky130_fd_sc_hd__decap_8
XFILLER_0_11_66 VPWR VGND VPWR VGND sky130_ef_sc_hd__decap_12
XFILLER_0_11_55 VGND VGND VPWR VPWR sky130_fd_sc_hd__fill_1
XFILLER_0_11_44 VGND VGND VPWR VPWR sky130_fd_sc_hd__decap_4
XFILLER_0_23_165 VGND VGND VPWR VPWR sky130_fd_sc_hd__decap_3
X_2520_ _1700_ _1702_ VGND VGND VPWR VPWR _1703_ sky130_fd_sc_hd__nor2_1
XFILLER_0_11_349 VPWR VGND VPWR VGND sky130_ef_sc_hd__decap_12
XFILLER_0_11_316 VPWR VGND VPWR VGND sky130_ef_sc_hd__decap_12
X_2451_ _1638_ _1640_ _1634_ VGND VGND VPWR VPWR _1641_ sky130_fd_sc_hd__o21ai_1
X_2382_ net46 _1580_ _1581_ add_tmp\[19\] _1584_ VGND VGND VPWR VPWR _0021_ sky130_fd_sc_hd__a221o_1
X_4121_ _1262_ _1263_ VGND VGND VPWR VPWR _1264_ sky130_fd_sc_hd__nand2_1
X_4052_ _1187_ _1188_ VGND VGND VPWR VPWR _1190_ sky130_fd_sc_hd__nand2_1
Xinput4 in_a[10] VGND VGND VPWR VPWR net4 sky130_fd_sc_hd__clkbuf_2
X_3003_ net6 VGND VGND VPWR VPWR _0120_ sky130_fd_sc_hd__buf_4
XFILLER_0_36_85 VGND VGND VPWR VPWR sky130_fd_sc_hd__fill_2
X_3905_ _0991_ _0992_ _1029_ _1030_ VGND VGND VPWR VPWR _1031_ sky130_fd_sc_hd__o211a_1
XFILLER_0_19_449 VPWR VGND VPWR VGND sky130_ef_sc_hd__decap_12
XFILLER_0_46_224 VGND VGND VPWR VPWR sky130_fd_sc_hd__fill_1
XFILLER_0_46_235 VPWR VGND VPWR VGND sky130_ef_sc_hd__decap_12
XFILLER_0_52_95 VGND VGND VPWR VPWR sky130_fd_sc_hd__fill_2
X_3836_ _0932_ _0933_ _0954_ _0955_ VGND VGND VPWR VPWR _0956_ sky130_fd_sc_hd__a22o_1
XFILLER_0_6_321 VGND VGND VPWR VPWR sky130_fd_sc_hd__decap_6
XFILLER_0_14_121 VPWR VGND VPWR VGND sky130_ef_sc_hd__decap_12
X_3767_ _0877_ _0878_ _0879_ VGND VGND VPWR VPWR _0881_ sky130_fd_sc_hd__a21oi_2
XFILLER_0_6_365 VPWR VGND VPWR VGND sky130_ef_sc_hd__decap_12
XFILLER_0_61_238 VGND VGND VPWR VPWR sky130_fd_sc_hd__decap_3
X_2718_ _1729_ VGND VGND VPWR VPWR _1896_ sky130_fd_sc_hd__clkbuf_2
X_3698_ _0677_ _0726_ _0806_ VGND VGND VPWR VPWR _0807_ sky130_fd_sc_hd__a21oi_1
X_2649_ _1671_ _1774_ _1827_ _1657_ VGND VGND VPWR VPWR _1828_ sky130_fd_sc_hd__a22o_1
XFILLER_0_10_371 VGND VGND VPWR VPWR sky130_fd_sc_hd__fill_1
X_4319_ clknet_3_1__leaf_clk _0064_ net35 VGND VGND VPWR VPWR add_tmp\[26\] sky130_fd_sc_hd__dfrtp_1
XFILLER_0_77_393 VGND VGND VPWR VPWR sky130_fd_sc_hd__fill_2
XFILLER_0_9_181 VPWR VGND VPWR VGND sky130_ef_sc_hd__decap_12
XFILLER_0_37_268 VGND VGND VPWR VPWR sky130_fd_sc_hd__fill_2
XFILLER_0_73_39 VPWR VGND VPWR VGND sky130_ef_sc_hd__decap_12
XFILLER_0_28_246 VGND VGND VPWR VPWR sky130_fd_sc_hd__decap_6
X_3621_ _0727_ _0730_ VGND VGND VPWR VPWR _0731_ sky130_fd_sc_hd__xnor2_1
X_3552_ _0661_ _0662_ VGND VGND VPWR VPWR _0663_ sky130_fd_sc_hd__xor2_2
XFILLER_0_3_335 VGND VGND VPWR VPWR sky130_fd_sc_hd__fill_1
XFILLER_0_11_113 VGND VGND VPWR VPWR sky130_fd_sc_hd__fill_2
XFILLER_0_11_102 VGND VGND VPWR VPWR sky130_fd_sc_hd__decap_8
XFILLER_0_3_379 VGND VGND VPWR VPWR sky130_fd_sc_hd__fill_1
X_2503_ _1686_ VGND VGND VPWR VPWR _1687_ sky130_fd_sc_hd__buf_2
X_3483_ _0593_ _0594_ VGND VGND VPWR VPWR _0595_ sky130_fd_sc_hd__xnor2_1
X_2434_ net57 _1580_ _1581_ add_tmp\[29\] _1626_ VGND VGND VPWR VPWR _0031_ sky130_fd_sc_hd__a221o_1
X_2365_ _1570_ VGND VGND VPWR VPWR _0018_ sky130_fd_sc_hd__clkbuf_1
X_4104_ _1234_ _1236_ _1245_ VGND VGND VPWR VPWR _1246_ sky130_fd_sc_hd__and3_1
X_2296_ _1487_ VGND VGND VPWR VPWR _1514_ sky130_fd_sc_hd__clkbuf_2
X_4035_ _1171_ VGND VGND VPWR VPWR _1172_ sky130_fd_sc_hd__inv_2
XFILLER_0_2_53 VPWR VGND VPWR VGND sky130_ef_sc_hd__decap_12
XPHY_108 VGND VGND VPWR VPWR sky130_fd_sc_hd__decap_3
XPHY_119 VGND VGND VPWR VPWR sky130_fd_sc_hd__decap_3
XFILLER_0_19_235 VPWR VGND VPWR VGND sky130_ef_sc_hd__decap_12
XFILLER_0_59_393 VGND VGND VPWR VPWR sky130_fd_sc_hd__fill_1
XFILLER_0_74_374 VGND VGND VPWR VPWR sky130_fd_sc_hd__decap_4
XFILLER_0_74_352 VGND VGND VPWR VPWR sky130_fd_sc_hd__fill_1
XFILLER_0_19_279 VGND VGND VPWR VPWR sky130_fd_sc_hd__fill_1
X_3819_ _1894_ VGND VGND VPWR VPWR _0937_ sky130_fd_sc_hd__inv_2
XFILLER_0_27_290 VPWR VGND VPWR VGND sky130_ef_sc_hd__decap_12
XFILLER_0_34_249 VGND VGND VPWR VPWR sky130_fd_sc_hd__decap_3
XFILLER_0_30_411 VGND VGND VPWR VPWR sky130_fd_sc_hd__fill_1
XFILLER_0_30_433 VGND VGND VPWR VPWR sky130_fd_sc_hd__decap_3
XFILLER_0_69_113 VGND VGND VPWR VPWR sky130_fd_sc_hd__fill_1
XFILLER_0_65_396 VPWR VGND VPWR VGND sky130_ef_sc_hd__decap_12
XFILLER_0_0_305 VGND VGND VPWR VPWR sky130_fd_sc_hd__decap_3
XFILLER_0_0_327 VGND VGND VPWR VPWR sky130_fd_sc_hd__decap_8
XFILLER_0_33_293 VGND VGND VPWR VPWR sky130_fd_sc_hd__decap_6
XTAP_606 VGND VPWR sky130_fd_sc_hd__tapvpwrvgnd_1
XTAP_617 VGND VPWR sky130_fd_sc_hd__tapvpwrvgnd_1
XTAP_628 VGND VPWR sky130_fd_sc_hd__tapvpwrvgnd_1
XTAP_639 VGND VPWR sky130_fd_sc_hd__tapvpwrvgnd_1
X_2150_ net67 add_tmp\[5\] VGND VGND VPWR VPWR _1070_ sky130_fd_sc_hd__or2_1
XFILLER_0_33_42 VPWR VGND VPWR VGND sky130_ef_sc_hd__decap_12
XFILLER_0_8_405 VPWR VGND VPWR VGND sky130_ef_sc_hd__decap_12
X_2983_ _1897_ VGND VGND VPWR VPWR _0100_ sky130_fd_sc_hd__buf_2
XFILLER_0_33_97 VPWR VGND VPWR VGND sky130_ef_sc_hd__decap_12
XFILLER_0_31_208 VGND VGND VPWR VPWR sky130_fd_sc_hd__fill_1
XFILLER_0_71_355 VGND VGND VPWR VPWR sky130_fd_sc_hd__fill_1
X_3604_ _0642_ _0643_ _0646_ _0649_ VGND VGND VPWR VPWR _0714_ sky130_fd_sc_hd__a31o_1
XFILLER_0_12_433 VPWR VGND VPWR VGND sky130_ef_sc_hd__decap_12
XFILLER_0_24_282 VPWR VGND VPWR VGND sky130_ef_sc_hd__decap_12
X_3535_ _0529_ _0645_ VGND VGND VPWR VPWR _0646_ sky130_fd_sc_hd__and2_1
X_3466_ _0575_ _0576_ _0560_ VGND VGND VPWR VPWR _0578_ sky130_fd_sc_hd__a21oi_1
X_2417_ _1577_ _1612_ VGND VGND VPWR VPWR _1613_ sky130_fd_sc_hd__nor2_1
X_3397_ _0509_ _0322_ _0413_ _0414_ VGND VGND VPWR VPWR _0510_ sky130_fd_sc_hd__o211ai_1
X_2348_ _1555_ _1556_ VGND VGND VPWR VPWR _1557_ sky130_fd_sc_hd__xnor2_1
X_2279_ _1497_ _1498_ _1499_ VGND VGND VPWR VPWR _1500_ sky130_fd_sc_hd__a21o_1
X_4018_ _1127_ _1152_ VGND VGND VPWR VPWR _1153_ sky130_fd_sc_hd__xor2_1
XFILLER_0_66_138 VGND VGND VPWR VPWR sky130_fd_sc_hd__fill_2
XFILLER_0_15_293 VPWR VGND VPWR VGND sky130_ef_sc_hd__decap_12
XFILLER_0_57_105 VGND VGND VPWR VPWR sky130_fd_sc_hd__decap_6
XFILLER_0_65_193 VPWR VGND VPWR VGND sky130_ef_sc_hd__decap_12
XFILLER_0_53_355 VPWR VGND VPWR VGND sky130_ef_sc_hd__decap_12
XFILLER_0_0_113 VGND VGND VPWR VPWR sky130_fd_sc_hd__fill_2
X_3320_ _0270_ VGND VGND VPWR VPWR _0433_ sky130_fd_sc_hd__clkbuf_2
XFILLER_0_21_274 VGND VGND VPWR VPWR sky130_fd_sc_hd__decap_6
XTAP_403 VGND VPWR sky130_fd_sc_hd__tapvpwrvgnd_1
XTAP_414 VGND VPWR sky130_fd_sc_hd__tapvpwrvgnd_1
XTAP_425 VGND VPWR sky130_fd_sc_hd__tapvpwrvgnd_1
XTAP_436 VGND VPWR sky130_fd_sc_hd__tapvpwrvgnd_1
XTAP_447 VGND VPWR sky130_fd_sc_hd__tapvpwrvgnd_1
XTAP_458 VGND VPWR sky130_fd_sc_hd__tapvpwrvgnd_1
X_3251_ _0287_ _0325_ _0363_ _0364_ VGND VGND VPWR VPWR _0365_ sky130_fd_sc_hd__a211oi_4
X_2202_ net50 add_tmp\[22\] VGND VGND VPWR VPWR _1426_ sky130_fd_sc_hd__or2_1
XTAP_469 VGND VPWR sky130_fd_sc_hd__tapvpwrvgnd_1
X_3182_ net107 _0196_ _0295_ _0296_ VGND VGND VPWR VPWR _0297_ sky130_fd_sc_hd__o211a_1
X_2133_ net43 add_tmp\[16\] VGND VGND VPWR VPWR _0886_ sky130_fd_sc_hd__or2_1
XFILLER_0_14_7 VGND VGND VPWR VPWR sky130_fd_sc_hd__fill_1
XFILLER_0_44_41 VGND VGND VPWR VPWR sky130_fd_sc_hd__fill_1
XFILLER_0_29_330 VGND VGND VPWR VPWR sky130_fd_sc_hd__decap_6
XFILLER_0_8_213 VPWR VGND VPWR VGND sky130_ef_sc_hd__decap_12
XFILLER_0_29_374 VPWR VGND VPWR VGND sky130_ef_sc_hd__decap_12
XFILLER_0_8_246 VGND VGND VPWR VPWR sky130_fd_sc_hd__decap_6
X_2966_ net20 VGND VGND VPWR VPWR _0083_ sky130_fd_sc_hd__buf_2
X_2897_ _2005_ _2027_ _2028_ VGND VGND VPWR VPWR _2072_ sky130_fd_sc_hd__nand3_1
XFILLER_0_8_96 VGND VGND VPWR VPWR sky130_fd_sc_hd__fill_1
XFILLER_0_12_285 VPWR VGND VPWR VGND sky130_ef_sc_hd__decap_12
X_3518_ _0354_ VGND VGND VPWR VPWR _0629_ sky130_fd_sc_hd__dlymetal6s2s_1
X_3449_ _2085_ VGND VGND VPWR VPWR _0561_ sky130_fd_sc_hd__clkbuf_2
XFILLER_0_39_105 VGND VGND VPWR VPWR sky130_fd_sc_hd__decap_6
XFILLER_0_67_436 VPWR VGND VPWR VGND sky130_ef_sc_hd__decap_12
XFILLER_0_62_141 VGND VGND VPWR VPWR sky130_fd_sc_hd__decap_6
XFILLER_0_50_303 VGND VGND VPWR VPWR sky130_fd_sc_hd__decap_4
XFILLER_0_73_417 VPWR VGND VPWR VGND sky130_ef_sc_hd__decap_12
X_2820_ net15 VGND VGND VPWR VPWR _1996_ sky130_fd_sc_hd__dlymetal6s2s_1
X_2751_ _1927_ _1837_ VGND VGND VPWR VPWR _1928_ sky130_fd_sc_hd__nand2_1
XFILLER_0_26_377 VGND VGND VPWR VPWR sky130_fd_sc_hd__decap_8
X_2682_ _1809_ _1808_ VGND VGND VPWR VPWR _1861_ sky130_fd_sc_hd__or2_1
X_4283_ clknet_3_2__leaf_clk _0028_ net35 VGND VGND VPWR VPWR net54 sky130_fd_sc_hd__dfrtp_4
XTAP_233 VGND VPWR sky130_fd_sc_hd__tapvpwrvgnd_1
XTAP_222 VGND VPWR sky130_fd_sc_hd__tapvpwrvgnd_1
XTAP_211 VGND VPWR sky130_fd_sc_hd__tapvpwrvgnd_1
XTAP_200 VGND VPWR sky130_fd_sc_hd__tapvpwrvgnd_1
X_3303_ _0415_ _0416_ VGND VGND VPWR VPWR _0417_ sky130_fd_sc_hd__nor2_2
XTAP_266 VGND VPWR sky130_fd_sc_hd__tapvpwrvgnd_1
XTAP_255 VGND VPWR sky130_fd_sc_hd__tapvpwrvgnd_1
XTAP_244 VGND VPWR sky130_fd_sc_hd__tapvpwrvgnd_1
X_3234_ _0346_ _0338_ _0339_ VGND VGND VPWR VPWR _0348_ sky130_fd_sc_hd__nand3_1
XTAP_299 VGND VPWR sky130_fd_sc_hd__tapvpwrvgnd_1
XTAP_288 VGND VPWR sky130_fd_sc_hd__tapvpwrvgnd_1
XTAP_277 VGND VPWR sky130_fd_sc_hd__tapvpwrvgnd_1
X_3165_ _1706_ _0192_ _2016_ _2096_ VGND VGND VPWR VPWR _0280_ sky130_fd_sc_hd__and4_1
X_3096_ _0107_ _0210_ _0211_ VGND VGND VPWR VPWR _0212_ sky130_fd_sc_hd__a21bo_1
XFILLER_0_76_233 VGND VGND VPWR VPWR sky130_fd_sc_hd__decap_6
XFILLER_0_71_83 VPWR VGND VPWR VGND sky130_ef_sc_hd__decap_12
XFILLER_0_17_322 VPWR VGND VPWR VGND sky130_ef_sc_hd__decap_12
X_3998_ _0534_ VGND VGND VPWR VPWR _1131_ sky130_fd_sc_hd__clkbuf_2
XFILLER_0_64_428 VGND VGND VPWR VPWR sky130_fd_sc_hd__fill_1
XFILLER_0_29_193 VGND VGND VPWR VPWR sky130_fd_sc_hd__fill_1
XFILLER_0_44_141 VGND VGND VPWR VPWR sky130_fd_sc_hd__decap_4
X_2949_ _2122_ _2123_ VGND VGND VPWR VPWR _2124_ sky130_fd_sc_hd__and2_1
XFILLER_0_32_347 VPWR VGND VPWR VGND sky130_ef_sc_hd__decap_12
XFILLER_0_31_391 VGND VGND VPWR VPWR sky130_fd_sc_hd__fill_1
XFILLER_0_58_233 VPWR VGND VPWR VGND sky130_ef_sc_hd__decap_12
XFILLER_0_18_108 VPWR VGND VPWR VGND sky130_ef_sc_hd__decap_12
X_3921_ _0972_ _0977_ _1045_ _1046_ VGND VGND VPWR VPWR _1048_ sky130_fd_sc_hd__a211o_2
XFILLER_0_46_406 VPWR VGND VPWR VGND sky130_ef_sc_hd__decap_12
X_3852_ _0970_ _0971_ _0884_ _0898_ VGND VGND VPWR VPWR _0974_ sky130_fd_sc_hd__a211o_1
XFILLER_0_58_288 VGND VGND VPWR VPWR sky130_fd_sc_hd__decap_6
XFILLER_0_73_203 VGND VGND VPWR VPWR sky130_fd_sc_hd__decap_8
X_2803_ _1978_ _1979_ VGND VGND VPWR VPWR _1980_ sky130_fd_sc_hd__and2_1
XFILLER_0_14_303 VGND VGND VPWR VPWR sky130_fd_sc_hd__decap_4
X_3783_ _0896_ _0898_ VGND VGND VPWR VPWR _0899_ sky130_fd_sc_hd__or2_1
X_2734_ _1815_ _1819_ _1822_ VGND VGND VPWR VPWR _1912_ sky130_fd_sc_hd__or3_1
X_2665_ _1697_ _1782_ _1727_ _1715_ VGND VGND VPWR VPWR _1844_ sky130_fd_sc_hd__and4_1
XFILLER_0_1_241 VPWR VGND VPWR VGND sky130_ef_sc_hd__decap_12
XFILLER_0_41_177 VGND VGND VPWR VPWR sky130_fd_sc_hd__fill_1
X_2596_ _1730_ _1722_ VGND VGND VPWR VPWR _1776_ sky130_fd_sc_hd__and2_1
XFILLER_0_5_53 VGND VGND VPWR VPWR sky130_fd_sc_hd__decap_3
XFILLER_0_5_75 VPWR VGND VPWR VGND sky130_ef_sc_hd__decap_12
X_4266_ clknet_3_7__leaf_clk _0011_ net35 VGND VGND VPWR VPWR net71 sky130_fd_sc_hd__dfrtp_4
X_4197_ _0869_ _1257_ _1288_ VGND VGND VPWR VPWR _1346_ sky130_fd_sc_hd__or3b_2
X_3217_ net9 VGND VGND VPWR VPWR _0331_ sky130_fd_sc_hd__clkbuf_2
X_3148_ _0261_ net147 _0259_ VGND VGND VPWR VPWR _0263_ sky130_fd_sc_hd__nor3_2
XFILLER_0_49_200 VGND VGND VPWR VPWR sky130_fd_sc_hd__fill_1
X_3079_ _1892_ _0191_ _0193_ _0194_ VGND VGND VPWR VPWR _0195_ sky130_fd_sc_hd__o2bb2a_1
XFILLER_0_37_417 VGND VGND VPWR VPWR sky130_fd_sc_hd__decap_3
XFILLER_0_64_203 VGND VGND VPWR VPWR sky130_fd_sc_hd__fill_1
XFILLER_0_17_152 VGND VGND VPWR VPWR sky130_fd_sc_hd__decap_8
XFILLER_0_32_155 VGND VGND VPWR VPWR sky130_fd_sc_hd__decap_8
XFILLER_0_13_380 VGND VGND VPWR VPWR sky130_fd_sc_hd__decap_6
XFILLER_0_13_391 VGND VGND VPWR VPWR sky130_fd_sc_hd__fill_1
XFILLER_0_28_439 VGND VGND VPWR VPWR sky130_fd_sc_hd__decap_3
XFILLER_0_11_78 VPWR VGND VPWR VGND sky130_ef_sc_hd__decap_12
XFILLER_0_11_328 VGND VGND VPWR VPWR sky130_fd_sc_hd__decap_8
X_2450_ _1516_ _1639_ VGND VGND VPWR VPWR _1640_ sky130_fd_sc_hd__or2b_1
XFILLER_0_23_177 VGND VGND VPWR VPWR sky130_fd_sc_hd__fill_1
X_2381_ _1499_ _1583_ VGND VGND VPWR VPWR _1584_ sky130_fd_sc_hd__nor2_1
X_4120_ _1255_ _1261_ VGND VGND VPWR VPWR _1263_ sky130_fd_sc_hd__or2_1
X_4051_ _0157_ _0858_ _1133_ _0868_ VGND VGND VPWR VPWR _1188_ sky130_fd_sc_hd__nand4_2
XFILLER_0_39_9 VGND VGND VPWR VPWR sky130_fd_sc_hd__decap_4
Xinput5 in_a[11] VGND VGND VPWR VPWR net5 sky130_fd_sc_hd__clkbuf_2
XFILLER_0_36_64 VPWR VGND VPWR VGND sky130_ef_sc_hd__decap_12
X_3002_ _0117_ _1937_ _2094_ _0118_ VGND VGND VPWR VPWR _0119_ sky130_fd_sc_hd__nand4_4
XFILLER_0_19_406 VGND VGND VPWR VPWR sky130_fd_sc_hd__fill_2
X_3904_ _1006_ _1007_ _1026_ _1028_ VGND VGND VPWR VPWR _1030_ sky130_fd_sc_hd__or4_4
XFILLER_0_46_247 VGND VGND VPWR VPWR sky130_fd_sc_hd__fill_1
X_3835_ _0948_ _0949_ _0953_ VGND VGND VPWR VPWR _0955_ sky130_fd_sc_hd__a21o_1
XFILLER_0_27_461 VGND VGND VPWR VPWR sky130_fd_sc_hd__fill_2
X_3766_ _0877_ _0878_ _0879_ VGND VGND VPWR VPWR _0880_ sky130_fd_sc_hd__and3_2
XFILLER_0_6_377 VGND VGND VPWR VPWR sky130_fd_sc_hd__decap_8
XFILLER_0_14_133 VGND VGND VPWR VPWR sky130_fd_sc_hd__fill_1
X_2717_ _1894_ VGND VGND VPWR VPWR _1895_ sky130_fd_sc_hd__clkbuf_2
XFILLER_0_14_177 VPWR VGND VPWR VGND sky130_ef_sc_hd__decap_12
X_3697_ _0725_ _0723_ VGND VGND VPWR VPWR _0806_ sky130_fd_sc_hd__and2b_1
XFILLER_0_72_3 VPWR VGND VPWR VGND sky130_ef_sc_hd__decap_12
X_2648_ net16 VGND VGND VPWR VPWR _1827_ sky130_fd_sc_hd__clkbuf_2
X_2579_ net3 _1759_ _1756_ _1757_ VGND VGND VPWR VPWR _1760_ sky130_fd_sc_hd__o2bb2a_1
X_4318_ clknet_3_0__leaf_clk _0063_ net35 VGND VGND VPWR VPWR add_tmp\[25\] sky130_fd_sc_hd__dfrtp_1
X_4249_ _1394_ _1400_ VGND VGND VPWR VPWR _1401_ sky130_fd_sc_hd__xor2_1
XFILLER_0_77_350 VPWR VGND VPWR VGND sky130_ef_sc_hd__decap_12
XFILLER_0_37_203 VGND VGND VPWR VPWR sky130_fd_sc_hd__fill_1
XFILLER_0_18_450 VPWR VGND VPWR VGND sky130_ef_sc_hd__decap_12
XFILLER_0_9_193 VGND VGND VPWR VPWR sky130_fd_sc_hd__decap_6
XFILLER_0_28_214 VPWR VGND VPWR VGND sky130_ef_sc_hd__decap_12
XFILLER_0_22_11 VGND VGND VPWR VPWR sky130_fd_sc_hd__fill_1
X_3620_ _0607_ _0728_ _0729_ VGND VGND VPWR VPWR _0730_ sky130_fd_sc_hd__o21a_1
X_3551_ _0515_ _0588_ _0587_ VGND VGND VPWR VPWR _0662_ sky130_fd_sc_hd__o21ba_1
X_2502_ _1685_ VGND VGND VPWR VPWR _1686_ sky130_fd_sc_hd__clkbuf_2
XFILLER_0_11_136 VGND VGND VPWR VPWR sky130_fd_sc_hd__fill_1
X_3482_ _0507_ _0512_ _0505_ VGND VGND VPWR VPWR _0594_ sky130_fd_sc_hd__o21bai_1
X_2433_ _1499_ _1625_ VGND VGND VPWR VPWR _1626_ sky130_fd_sc_hd__nor2_1
X_2364_ net43 _1569_ _1553_ VGND VGND VPWR VPWR _1570_ sky130_fd_sc_hd__mux2_1
X_4103_ _1129_ _1244_ VGND VGND VPWR VPWR _1245_ sky130_fd_sc_hd__xnor2_1
X_2295_ net65 _1502_ _1504_ add_tmp\[3\] _1513_ VGND VGND VPWR VPWR _0005_ sky130_fd_sc_hd__a221o_1
X_4034_ _1101_ _1123_ _1169_ _1170_ VGND VGND VPWR VPWR _1171_ sky130_fd_sc_hd__a211oi_4
XFILLER_0_2_65 VGND VGND VPWR VPWR sky130_fd_sc_hd__fill_1
XFILLER_0_63_51 VGND VGND VPWR VPWR sky130_fd_sc_hd__decap_4
XFILLER_0_66_309 VGND VGND VPWR VPWR sky130_fd_sc_hd__decap_4
XPHY_109 VGND VGND VPWR VPWR sky130_fd_sc_hd__decap_3
XFILLER_0_19_225 VGND VGND VPWR VPWR sky130_fd_sc_hd__decap_3
XFILLER_0_19_247 VPWR VGND VPWR VGND sky130_ef_sc_hd__decap_12
X_3818_ _0205_ _0335_ _0934_ _0935_ VGND VGND VPWR VPWR _0936_ sky130_fd_sc_hd__a22o_1
XFILLER_0_34_228 VGND VGND VPWR VPWR sky130_fd_sc_hd__fill_1
X_3749_ _1799_ _1818_ _0335_ _0530_ VGND VGND VPWR VPWR _0861_ sky130_fd_sc_hd__nand4_2
XFILLER_0_42_250 VGND VGND VPWR VPWR sky130_fd_sc_hd__fill_2
XFILLER_0_42_261 VGND VGND VPWR VPWR sky130_fd_sc_hd__fill_1
XFILLER_0_10_191 VGND VGND VPWR VPWR sky130_fd_sc_hd__decap_4
XFILLER_0_57_309 VGND VGND VPWR VPWR sky130_fd_sc_hd__fill_1
XFILLER_0_69_169 VGND VGND VPWR VPWR sky130_fd_sc_hd__decap_6
XFILLER_0_77_191 VGND VGND VPWR VPWR sky130_fd_sc_hd__decap_4
XFILLER_0_18_280 VGND VGND VPWR VPWR sky130_fd_sc_hd__decap_6
XFILLER_0_21_412 VPWR VGND VPWR VGND sky130_ef_sc_hd__decap_12
XFILLER_0_68_29 VPWR VGND VPWR VGND sky130_ef_sc_hd__decap_12
XTAP_607 VGND VPWR sky130_fd_sc_hd__tapvpwrvgnd_1
XTAP_618 VGND VPWR sky130_fd_sc_hd__tapvpwrvgnd_1
XTAP_629 VGND VPWR sky130_fd_sc_hd__tapvpwrvgnd_1
XFILLER_0_17_99 VGND VGND VPWR VPWR sky130_fd_sc_hd__fill_2
XFILLER_0_8_417 VGND VGND VPWR VPWR sky130_fd_sc_hd__decap_3
XFILLER_0_33_54 VGND VGND VPWR VPWR sky130_fd_sc_hd__fill_2
XFILLER_0_33_65 VGND VGND VPWR VPWR sky130_fd_sc_hd__decap_8
X_2982_ _1927_ _1895_ VGND VGND VPWR VPWR _0099_ sky130_fd_sc_hd__nand2_1
Xinput30 in_b[5] VGND VGND VPWR VPWR net30 sky130_fd_sc_hd__buf_2
X_3603_ _0647_ _0710_ _0711_ VGND VGND VPWR VPWR _0713_ sky130_fd_sc_hd__nand3_1
XFILLER_0_12_445 VPWR VGND VPWR VGND sky130_ef_sc_hd__decap_12
XFILLER_0_3_177 VGND VGND VPWR VPWR sky130_fd_sc_hd__fill_2
XFILLER_0_24_294 VPWR VGND VPWR VGND sky130_ef_sc_hd__decap_12
X_3534_ net19 _1720_ net27 net9 VGND VGND VPWR VPWR _0645_ sky130_fd_sc_hd__o31a_2
X_3465_ _0560_ _0575_ _0576_ VGND VGND VPWR VPWR _0577_ sky130_fd_sc_hd__and3_1
X_2416_ _1607_ _1440_ _1446_ _1453_ VGND VGND VPWR VPWR _1612_ sky130_fd_sc_hd__o211a_1
X_3396_ _0227_ _0235_ _0309_ _0310_ VGND VGND VPWR VPWR _0509_ sky130_fd_sc_hd__o211a_1
XFILLER_0_35_3 VGND VGND VPWR VPWR sky130_fd_sc_hd__decap_8
X_2347_ _0984_ _0994_ _1351_ _0962_ VGND VGND VPWR VPWR _1556_ sky130_fd_sc_hd__o31a_1
X_2278_ _1485_ VGND VGND VPWR VPWR _1499_ sky130_fd_sc_hd__buf_2
X_4017_ _1128_ _1151_ VGND VGND VPWR VPWR _1152_ sky130_fd_sc_hd__xnor2_1
XFILLER_0_74_83 VGND VGND VPWR VPWR sky130_fd_sc_hd__fill_1
XFILLER_0_47_320 VGND VGND VPWR VPWR sky130_fd_sc_hd__decap_8
XFILLER_0_74_161 VGND VGND VPWR VPWR sky130_fd_sc_hd__fill_1
XFILLER_0_62_356 VGND VGND VPWR VPWR sky130_fd_sc_hd__decap_8
XFILLER_0_74_194 VGND VGND VPWR VPWR sky130_fd_sc_hd__fill_2
XFILLER_0_15_261 VGND VGND VPWR VPWR sky130_fd_sc_hd__decap_8
XFILLER_0_30_231 VGND VGND VPWR VPWR sky130_fd_sc_hd__decap_4
XFILLER_0_30_253 VGND VGND VPWR VPWR sky130_fd_sc_hd__fill_1
XFILLER_0_38_353 VGND VGND VPWR VPWR sky130_fd_sc_hd__decap_8
XFILLER_0_72_109 VGND VGND VPWR VPWR sky130_fd_sc_hd__decap_3
XFILLER_0_53_367 VPWR VGND VPWR VGND sky130_ef_sc_hd__decap_12
XFILLER_0_0_103 VGND VGND VPWR VPWR sky130_fd_sc_hd__decap_8
XFILLER_0_0_169 VGND VGND VPWR VPWR sky130_fd_sc_hd__fill_2
XTAP_404 VGND VPWR sky130_fd_sc_hd__tapvpwrvgnd_1
XTAP_415 VGND VPWR sky130_fd_sc_hd__tapvpwrvgnd_1
XTAP_426 VGND VPWR sky130_fd_sc_hd__tapvpwrvgnd_1
XTAP_437 VGND VPWR sky130_fd_sc_hd__tapvpwrvgnd_1
XTAP_448 VGND VPWR sky130_fd_sc_hd__tapvpwrvgnd_1
X_3250_ _0362_ _0350_ _0351_ VGND VGND VPWR VPWR _0364_ sky130_fd_sc_hd__and3_1
X_2201_ net50 add_tmp\[22\] VGND VGND VPWR VPWR _1425_ sky130_fd_sc_hd__nand2_1
XTAP_459 VGND VPWR sky130_fd_sc_hd__tapvpwrvgnd_1
X_3181_ _1929_ _1895_ _0293_ _0294_ VGND VGND VPWR VPWR _0296_ sky130_fd_sc_hd__nand4_2
X_2132_ net43 add_tmp\[16\] VGND VGND VPWR VPWR _0875_ sky130_fd_sc_hd__nand2_1
XFILLER_0_44_20 VGND VGND VPWR VPWR sky130_fd_sc_hd__decap_8
XFILLER_0_48_139 VGND VGND VPWR VPWR sky130_fd_sc_hd__fill_1
XFILLER_0_8_225 VPWR VGND VPWR VGND sky130_ef_sc_hd__decap_12
X_2965_ _2061_ VGND VGND VPWR VPWR _0082_ sky130_fd_sc_hd__clkbuf_2
XFILLER_0_56_161 VGND VGND VPWR VPWR sky130_fd_sc_hd__fill_2
X_2896_ _2058_ _2070_ VGND VGND VPWR VPWR _2071_ sky130_fd_sc_hd__xnor2_1
XFILLER_0_60_85 VGND VGND VPWR VPWR sky130_fd_sc_hd__decap_4
XFILLER_0_12_253 VGND VGND VPWR VPWR sky130_fd_sc_hd__decap_4
X_3517_ _2008_ _0342_ _0537_ _0434_ _0536_ VGND VGND VPWR VPWR _0628_ sky130_fd_sc_hd__a32o_1
XFILLER_0_12_297 VGND VGND VPWR VPWR sky130_fd_sc_hd__decap_4
X_3448_ _0443_ _0452_ _0451_ VGND VGND VPWR VPWR _0560_ sky130_fd_sc_hd__a21o_1
X_3379_ _1681_ _0160_ _0382_ _0381_ _0080_ VGND VGND VPWR VPWR _0492_ sky130_fd_sc_hd__a32o_2
XFILLER_0_62_131 VGND VGND VPWR VPWR sky130_fd_sc_hd__decap_8
XFILLER_0_35_378 VGND VGND VPWR VPWR sky130_fd_sc_hd__decap_3
XFILLER_0_50_326 VGND VGND VPWR VPWR sky130_fd_sc_hd__decap_8
XFILLER_0_62_197 VPWR VGND VPWR VGND sky130_ef_sc_hd__decap_12
XFILLER_0_73_429 VPWR VGND VPWR VGND sky130_ef_sc_hd__decap_12
XFILLER_0_38_194 VGND VGND VPWR VPWR sky130_fd_sc_hd__fill_2
X_2750_ _1727_ VGND VGND VPWR VPWR _1927_ sky130_fd_sc_hd__buf_2
XFILLER_0_30_55 VPWR VGND VPWR VGND sky130_ef_sc_hd__decap_12
X_2681_ _1859_ VGND VGND VPWR VPWR _1860_ sky130_fd_sc_hd__clkbuf_2
XFILLER_0_53_153 VGND VGND VPWR VPWR sky130_fd_sc_hd__decap_4
XFILLER_0_41_337 VGND VGND VPWR VPWR sky130_fd_sc_hd__decap_4
X_4282_ clknet_3_2__leaf_clk _0027_ net35 VGND VGND VPWR VPWR net53 sky130_fd_sc_hd__dfrtp_4
XTAP_223 VGND VPWR sky130_fd_sc_hd__tapvpwrvgnd_1
XTAP_212 VGND VPWR sky130_fd_sc_hd__tapvpwrvgnd_1
XTAP_201 VGND VPWR sky130_fd_sc_hd__tapvpwrvgnd_1
X_3302_ _0311_ _0413_ _0414_ VGND VGND VPWR VPWR _0416_ sky130_fd_sc_hd__and3_1
XTAP_256 VGND VPWR sky130_fd_sc_hd__tapvpwrvgnd_1
XTAP_245 VGND VPWR sky130_fd_sc_hd__tapvpwrvgnd_1
XTAP_234 VGND VPWR sky130_fd_sc_hd__tapvpwrvgnd_1
X_3233_ _0338_ _0339_ _0346_ VGND VGND VPWR VPWR _0347_ sky130_fd_sc_hd__a21o_1
XTAP_289 VGND VPWR sky130_fd_sc_hd__tapvpwrvgnd_1
XTAP_278 VGND VPWR sky130_fd_sc_hd__tapvpwrvgnd_1
XTAP_267 VGND VPWR sky130_fd_sc_hd__tapvpwrvgnd_1
X_3164_ _1716_ _2093_ _0278_ _1881_ VGND VGND VPWR VPWR _0279_ sky130_fd_sc_hd__a22oi_1
XFILLER_0_55_41 VGND VGND VPWR VPWR sky130_fd_sc_hd__fill_2
XFILLER_0_55_52 VGND VGND VPWR VPWR sky130_fd_sc_hd__decap_4
X_3095_ _2077_ _1868_ _1898_ _1996_ VGND VGND VPWR VPWR _0211_ sky130_fd_sc_hd__a22o_1
XFILLER_0_64_418 VGND VGND VPWR VPWR sky130_fd_sc_hd__fill_2
X_3997_ _1129_ VGND VGND VPWR VPWR _1130_ sky130_fd_sc_hd__dlymetal6s2s_1
XFILLER_0_71_95 VGND VGND VPWR VPWR sky130_fd_sc_hd__decap_4
XFILLER_0_17_334 VGND VGND VPWR VPWR sky130_fd_sc_hd__fill_2
XFILLER_0_44_120 VGND VGND VPWR VPWR sky130_fd_sc_hd__decap_8
X_2948_ _2050_ _2049_ _2121_ VGND VGND VPWR VPWR _2123_ sky130_fd_sc_hd__a21o_1
XFILLER_0_44_153 VGND VGND VPWR VPWR sky130_fd_sc_hd__fill_1
XFILLER_0_72_462 VGND VGND VPWR VPWR sky130_fd_sc_hd__fill_1
XFILLER_0_32_326 VGND VGND VPWR VPWR sky130_fd_sc_hd__decap_4
X_2879_ _2053_ _2054_ net138 _1712_ VGND VGND VPWR VPWR _0048_ sky130_fd_sc_hd__a2bb2o_1
XFILLER_0_32_359 VGND VGND VPWR VPWR sky130_fd_sc_hd__decap_4
XTAP_790 VGND VPWR sky130_fd_sc_hd__tapvpwrvgnd_1
XFILLER_0_67_201 VPWR VGND VPWR VGND sky130_ef_sc_hd__decap_12
XFILLER_0_67_289 VGND VGND VPWR VPWR sky130_fd_sc_hd__fill_1
XFILLER_0_23_315 VGND VGND VPWR VPWR sky130_fd_sc_hd__fill_1
XFILLER_0_35_153 VGND VGND VPWR VPWR sky130_fd_sc_hd__decap_3
XFILLER_0_2_209 VGND VGND VPWR VPWR sky130_fd_sc_hd__fill_1
XFILLER_0_35_197 VGND VGND VPWR VPWR sky130_fd_sc_hd__fill_2
XFILLER_0_76_29 VPWR VGND VPWR VGND sky130_ef_sc_hd__decap_12
X_3920_ _1045_ _1046_ _0972_ _0977_ VGND VGND VPWR VPWR _1047_ sky130_fd_sc_hd__o211a_2
XFILLER_0_25_55 VGND VGND VPWR VPWR sky130_fd_sc_hd__fill_1
XFILLER_0_58_245 VGND VGND VPWR VPWR sky130_fd_sc_hd__decap_6
X_3851_ _0884_ _0898_ _0970_ _0971_ VGND VGND VPWR VPWR _0972_ sky130_fd_sc_hd__o211ai_4
XFILLER_0_46_418 VGND VGND VPWR VPWR sky130_fd_sc_hd__fill_2
X_3782_ _0895_ _0884_ _0885_ VGND VGND VPWR VPWR _0898_ sky130_fd_sc_hd__nor3_4
X_2802_ _1977_ _1969_ _1970_ VGND VGND VPWR VPWR _1979_ sky130_fd_sc_hd__nand3_1
XFILLER_0_41_98 VGND VGND VPWR VPWR sky130_fd_sc_hd__fill_2
X_2733_ _1908_ _1909_ _1851_ _1852_ VGND VGND VPWR VPWR _1911_ sky130_fd_sc_hd__o211a_1
X_2664_ _1839_ _1840_ _1841_ _1842_ VGND VGND VPWR VPWR _1843_ sky130_fd_sc_hd__a22oi_2
XFILLER_0_41_134 VGND VGND VPWR VPWR sky130_fd_sc_hd__fill_2
XFILLER_0_41_145 VPWR VGND VPWR VGND sky130_ef_sc_hd__decap_12
X_2595_ _1725_ _1726_ _1744_ _1774_ VGND VGND VPWR VPWR _1775_ sky130_fd_sc_hd__nand4_2
XFILLER_0_5_21 VPWR VGND VPWR VGND sky130_ef_sc_hd__decap_12
XFILLER_0_1_253 VPWR VGND VPWR VGND sky130_ef_sc_hd__decap_12
XFILLER_0_1_275 VGND VGND VPWR VPWR sky130_fd_sc_hd__decap_4
XFILLER_0_5_87 VPWR VGND VPWR VGND sky130_ef_sc_hd__decap_12
X_4265_ clknet_3_6__leaf_clk _0010_ net35 VGND VGND VPWR VPWR net70 sky130_fd_sc_hd__dfrtp_4
X_4196_ _1284_ _1296_ _1294_ VGND VGND VPWR VPWR _1345_ sky130_fd_sc_hd__a21o_1
X_3216_ _1658_ _0328_ _0329_ VGND VGND VPWR VPWR _0330_ sky130_fd_sc_hd__a21o_1
X_3147_ _0258_ _0259_ _0261_ VGND VGND VPWR VPWR _0262_ sky130_fd_sc_hd__o21a_1
X_3078_ _1753_ _1715_ net18 _2092_ VGND VGND VPWR VPWR _0194_ sky130_fd_sc_hd__and4_1
XFILLER_0_49_223 VGND VGND VPWR VPWR sky130_fd_sc_hd__fill_1
XFILLER_0_49_278 VGND VGND VPWR VPWR sky130_fd_sc_hd__fill_2
XFILLER_0_9_397 VGND VGND VPWR VPWR sky130_fd_sc_hd__decap_3
XFILLER_0_17_197 VGND VGND VPWR VPWR sky130_fd_sc_hd__decap_8
XFILLER_0_32_123 VPWR VGND VPWR VGND sky130_ef_sc_hd__decap_12
XFILLER_0_60_421 VGND VGND VPWR VPWR sky130_fd_sc_hd__fill_1
XFILLER_0_70_218 VPWR VGND VPWR VGND sky130_ef_sc_hd__decap_12
XFILLER_0_23_123 VGND VGND VPWR VPWR sky130_fd_sc_hd__decap_6
XFILLER_0_63_270 VGND VGND VPWR VPWR sky130_fd_sc_hd__decap_8
XFILLER_0_23_134 VGND VGND VPWR VPWR sky130_fd_sc_hd__fill_1
XFILLER_0_23_189 VGND VGND VPWR VPWR sky130_fd_sc_hd__decap_4
X_2380_ _1410_ _1582_ VGND VGND VPWR VPWR _1583_ sky130_fd_sc_hd__xor2_1
X_4050_ _0858_ _1133_ _0868_ _0079_ VGND VGND VPWR VPWR _1187_ sky130_fd_sc_hd__a22o_1
Xinput6 in_a[12] VGND VGND VPWR VPWR net6 sky130_fd_sc_hd__clkbuf_2
X_3001_ net6 VGND VGND VPWR VPWR _0118_ sky130_fd_sc_hd__clkbuf_2
X_3903_ _1006_ _1007_ _1026_ _1028_ VGND VGND VPWR VPWR _1029_ sky130_fd_sc_hd__o22ai_1
X_3834_ _0948_ _0949_ _0953_ VGND VGND VPWR VPWR _0954_ sky130_fd_sc_hd__nand3_2
X_3765_ _0794_ _0797_ VGND VGND VPWR VPWR _0879_ sky130_fd_sc_hd__or2_1
XFILLER_0_42_421 VGND VGND VPWR VPWR sky130_fd_sc_hd__fill_1
XFILLER_0_14_145 VGND VGND VPWR VPWR sky130_fd_sc_hd__decap_8
X_2716_ net33 VGND VGND VPWR VPWR _1894_ sky130_fd_sc_hd__clkbuf_2
X_3696_ _0752_ _0804_ VGND VGND VPWR VPWR _0805_ sky130_fd_sc_hd__xor2_1
XFILLER_0_14_189 VGND VGND VPWR VPWR sky130_fd_sc_hd__decap_6
X_2647_ _1685_ _1825_ VGND VGND VPWR VPWR _1826_ sky130_fd_sc_hd__and2_1
XFILLER_0_65_3 VGND VGND VPWR VPWR sky130_fd_sc_hd__decap_8
XFILLER_0_10_351 VPWR VGND VPWR VGND sky130_ef_sc_hd__decap_12
X_2578_ net30 VGND VGND VPWR VPWR _1759_ sky130_fd_sc_hd__clkbuf_2
X_4317_ clknet_3_1__leaf_clk _0062_ net35 VGND VGND VPWR VPWR add_tmp\[24\] sky130_fd_sc_hd__dfrtp_1
X_4248_ _1398_ _1399_ VGND VGND VPWR VPWR _1400_ sky130_fd_sc_hd__xor2_1
X_4179_ _1117_ _1181_ _1324_ _1325_ _1326_ VGND VGND VPWR VPWR _1327_ sky130_fd_sc_hd__o311a_4
XFILLER_0_77_373 VPWR VGND VPWR VGND sky130_ef_sc_hd__decap_12
XFILLER_0_77_362 VGND VGND VPWR VPWR sky130_fd_sc_hd__fill_2
XFILLER_0_9_161 VGND VGND VPWR VPWR sky130_fd_sc_hd__decap_6
XFILLER_0_18_462 VGND VGND VPWR VPWR sky130_fd_sc_hd__fill_1
Xclkbuf_3_3__f_clk clknet_0_clk VGND VGND VPWR VPWR clknet_3_3__leaf_clk sky130_fd_sc_hd__clkbuf_16
XFILLER_0_45_281 VGND VGND VPWR VPWR sky130_fd_sc_hd__decap_6
XFILLER_0_60_251 VGND VGND VPWR VPWR sky130_fd_sc_hd__fill_1
XFILLER_0_60_262 VPWR VGND VPWR VGND sky130_ef_sc_hd__decap_12
XFILLER_0_20_159 VGND VGND VPWR VPWR sky130_fd_sc_hd__fill_1
XFILLER_0_68_362 VGND VGND VPWR VPWR sky130_fd_sc_hd__fill_2
XFILLER_0_28_226 VGND VGND VPWR VPWR sky130_fd_sc_hd__decap_4
XPHY_90 VGND VGND VPWR VPWR sky130_fd_sc_hd__decap_3
XFILLER_0_28_259 VGND VGND VPWR VPWR sky130_fd_sc_hd__fill_2
XFILLER_0_43_207 VGND VGND VPWR VPWR sky130_fd_sc_hd__fill_2
X_3550_ _0598_ _0660_ VGND VGND VPWR VPWR _0661_ sky130_fd_sc_hd__xor2_2
XFILLER_0_3_337 VPWR VGND VPWR VGND sky130_ef_sc_hd__decap_12
XFILLER_0_3_359 VPWR VGND VPWR VGND sky130_ef_sc_hd__decap_12
X_2501_ net27 VGND VGND VPWR VPWR _1685_ sky130_fd_sc_hd__clkbuf_2
X_3481_ _0591_ _0592_ VGND VGND VPWR VPWR _0593_ sky130_fd_sc_hd__or2_1
X_2432_ _1458_ _1624_ VGND VGND VPWR VPWR _1625_ sky130_fd_sc_hd__xor2_1
X_2363_ _1568_ add_tmp\[16\] _1522_ VGND VGND VPWR VPWR _1569_ sky130_fd_sc_hd__mux2_1
X_4102_ _1241_ _1242_ VGND VGND VPWR VPWR _1244_ sky130_fd_sc_hd__xor2_1
X_4033_ _1095_ _1106_ _1165_ _1167_ VGND VGND VPWR VPWR _1170_ sky130_fd_sc_hd__o211a_2
X_2294_ _1511_ _1512_ _1508_ VGND VGND VPWR VPWR _1513_ sky130_fd_sc_hd__o21a_1
XFILLER_0_37_7 VGND VGND VPWR VPWR sky130_fd_sc_hd__fill_1
XFILLER_0_74_332 VPWR VGND VPWR VGND sky130_ef_sc_hd__decap_12
XFILLER_0_19_259 VPWR VGND VPWR VGND sky130_ef_sc_hd__decap_12
X_3817_ _0100_ _1821_ _0332_ VGND VGND VPWR VPWR _0935_ sky130_fd_sc_hd__o21a_1
XFILLER_0_34_218 VGND VGND VPWR VPWR sky130_fd_sc_hd__decap_6
X_3748_ _1818_ _0536_ _0859_ _1799_ VGND VGND VPWR VPWR _0860_ sky130_fd_sc_hd__a22o_1
XFILLER_0_6_197 VPWR VGND VPWR VGND sky130_ef_sc_hd__decap_12
X_3679_ _0786_ _0784_ _0785_ VGND VGND VPWR VPWR _0788_ sky130_fd_sc_hd__and3_1
XFILLER_0_69_126 VGND VGND VPWR VPWR sky130_fd_sc_hd__fill_1
XFILLER_0_77_181 VGND VGND VPWR VPWR sky130_fd_sc_hd__decap_4
XFILLER_0_21_424 VGND VGND VPWR VPWR sky130_fd_sc_hd__decap_4
XFILLER_0_21_446 VGND VGND VPWR VPWR sky130_fd_sc_hd__fill_2
XFILLER_0_21_457 VGND VGND VPWR VPWR sky130_fd_sc_hd__fill_2
XTAP_608 VGND VPWR sky130_fd_sc_hd__tapvpwrvgnd_1
XTAP_619 VGND VPWR sky130_fd_sc_hd__tapvpwrvgnd_1
X_2981_ _1956_ _1997_ _2088_ net153 VGND VGND VPWR VPWR _0098_ sky130_fd_sc_hd__a31o_1
Xinput31 in_b[6] VGND VGND VPWR VPWR net31 sky130_fd_sc_hd__buf_6
X_3602_ _0710_ _0711_ _0646_ VGND VGND VPWR VPWR _0712_ sky130_fd_sc_hd__a21o_1
Xinput20 in_b[10] VGND VGND VPWR VPWR net20 sky130_fd_sc_hd__buf_2
XFILLER_0_71_335 VGND VGND VPWR VPWR sky130_fd_sc_hd__fill_1
XFILLER_0_3_167 VGND VGND VPWR VPWR sky130_fd_sc_hd__fill_1
X_3533_ _0642_ _0643_ VGND VGND VPWR VPWR _0644_ sky130_fd_sc_hd__nand2_1
XFILLER_0_12_457 VGND VGND VPWR VPWR sky130_fd_sc_hd__decap_3
X_3464_ _0574_ _0567_ _0568_ VGND VGND VPWR VPWR _0576_ sky130_fd_sc_hd__nand3_1
X_2415_ _1449_ _1607_ _1439_ _1446_ _1438_ VGND VGND VPWR VPWR _1611_ sky130_fd_sc_hd__a311o_1
XFILLER_0_58_41 VGND VGND VPWR VPWR sky130_fd_sc_hd__decap_3
X_3395_ _0314_ VGND VGND VPWR VPWR _0508_ sky130_fd_sc_hd__inv_2
X_2346_ _0951_ _1362_ VGND VGND VPWR VPWR _1555_ sky130_fd_sc_hd__or2b_1
X_2277_ _1135_ _1114_ _1124_ VGND VGND VPWR VPWR _1498_ sky130_fd_sc_hd__a21o_1
X_4016_ _1130_ _1150_ VGND VGND VPWR VPWR _1151_ sky130_fd_sc_hd__xor2_1
XFILLER_0_28_3 VGND VGND VPWR VPWR sky130_fd_sc_hd__decap_6
XFILLER_0_7_440 VGND VGND VPWR VPWR sky130_fd_sc_hd__decap_8
XFILLER_0_62_313 VGND VGND VPWR VPWR sky130_fd_sc_hd__decap_6
XFILLER_0_74_173 VPWR VGND VPWR VGND sky130_ef_sc_hd__decap_12
XFILLER_0_30_287 VPWR VGND VPWR VGND sky130_ef_sc_hd__decap_12
XFILLER_0_38_332 VPWR VGND VPWR VGND sky130_ef_sc_hd__decap_12
XFILLER_0_38_365 VGND VGND VPWR VPWR sky130_fd_sc_hd__decap_8
XFILLER_0_53_379 VPWR VGND VPWR VGND sky130_ef_sc_hd__decap_12
XTAP_405 VGND VPWR sky130_fd_sc_hd__tapvpwrvgnd_1
XTAP_416 VGND VPWR sky130_fd_sc_hd__tapvpwrvgnd_1
XTAP_427 VGND VPWR sky130_fd_sc_hd__tapvpwrvgnd_1
XTAP_438 VGND VPWR sky130_fd_sc_hd__tapvpwrvgnd_1
XTAP_449 VGND VPWR sky130_fd_sc_hd__tapvpwrvgnd_1
X_2200_ net51 add_tmp\[23\] VGND VGND VPWR VPWR _1424_ sky130_fd_sc_hd__or2_1
X_3180_ _1929_ _1903_ _0293_ _0294_ VGND VGND VPWR VPWR _0295_ sky130_fd_sc_hd__a22o_1
X_2131_ _0831_ net64 VGND VGND VPWR VPWR _0864_ sky130_fd_sc_hd__or2_1
XFILLER_0_44_65 VGND VGND VPWR VPWR sky130_fd_sc_hd__decap_3
X_2964_ _1662_ _0080_ VGND VGND VPWR VPWR _0081_ sky130_fd_sc_hd__nand2_1
XFILLER_0_8_237 VGND VGND VPWR VPWR sky130_fd_sc_hd__fill_1
XFILLER_0_56_195 VGND VGND VPWR VPWR sky130_fd_sc_hd__fill_1
X_2895_ _2068_ _2069_ VGND VGND VPWR VPWR _2070_ sky130_fd_sc_hd__or2_1
XFILLER_0_60_97 VGND VGND VPWR VPWR sky130_fd_sc_hd__fill_2
XFILLER_0_71_110 VGND VGND VPWR VPWR sky130_fd_sc_hd__fill_2
XFILLER_0_4_421 VPWR VGND VPWR VGND sky130_ef_sc_hd__decap_12
XFILLER_0_71_187 VGND VGND VPWR VPWR sky130_fd_sc_hd__fill_1
X_3516_ _0548_ _0549_ VGND VGND VPWR VPWR _0627_ sky130_fd_sc_hd__nand2_2
XFILLER_0_69_51 VGND VGND VPWR VPWR sky130_fd_sc_hd__decap_4
X_3447_ _0468_ _0480_ VGND VGND VPWR VPWR _0559_ sky130_fd_sc_hd__and2_1
X_3378_ _0387_ VGND VGND VPWR VPWR _0491_ sky130_fd_sc_hd__inv_2
X_2329_ net71 _1536_ _1537_ net139 _1541_ VGND VGND VPWR VPWR _0011_ sky130_fd_sc_hd__a221o_1
XFILLER_0_67_405 VGND VGND VPWR VPWR sky130_fd_sc_hd__decap_8
XFILLER_0_67_449 VPWR VGND VPWR VGND sky130_ef_sc_hd__decap_12
XFILLER_0_47_184 VGND VGND VPWR VPWR sky130_fd_sc_hd__fill_1
XFILLER_0_7_281 VPWR VGND VPWR VGND sky130_ef_sc_hd__decap_12
XFILLER_0_26_313 VGND VGND VPWR VPWR sky130_fd_sc_hd__decap_8
XFILLER_0_5_218 VGND VGND VPWR VPWR sky130_fd_sc_hd__decap_6
XFILLER_0_53_121 VGND VGND VPWR VPWR sky130_fd_sc_hd__fill_2
X_2680_ _1857_ _1858_ VGND VGND VPWR VPWR _1859_ sky130_fd_sc_hd__and2b_1
XFILLER_0_41_316 VGND VGND VPWR VPWR sky130_fd_sc_hd__fill_1
XFILLER_0_30_67 VGND VGND VPWR VPWR sky130_fd_sc_hd__decap_8
XFILLER_0_41_327 VGND VGND VPWR VPWR sky130_fd_sc_hd__decap_8
X_3301_ _0413_ _0414_ _0311_ VGND VGND VPWR VPWR _0415_ sky130_fd_sc_hd__a21oi_2
XTAP_224 VGND VPWR sky130_fd_sc_hd__tapvpwrvgnd_1
XTAP_213 VGND VPWR sky130_fd_sc_hd__tapvpwrvgnd_1
XTAP_202 VGND VPWR sky130_fd_sc_hd__tapvpwrvgnd_1
X_4281_ clknet_3_2__leaf_clk _0026_ net35 VGND VGND VPWR VPWR net52 sky130_fd_sc_hd__dfrtp_4
XFILLER_0_39_54 VGND VGND VPWR VPWR sky130_fd_sc_hd__fill_2
XTAP_257 VGND VPWR sky130_fd_sc_hd__tapvpwrvgnd_1
XTAP_246 VGND VPWR sky130_fd_sc_hd__tapvpwrvgnd_1
XTAP_235 VGND VPWR sky130_fd_sc_hd__tapvpwrvgnd_1
X_3232_ _0341_ _0345_ VGND VGND VPWR VPWR _0346_ sky130_fd_sc_hd__xnor2_1
XTAP_279 VGND VPWR sky130_fd_sc_hd__tapvpwrvgnd_1
XTAP_268 VGND VPWR sky130_fd_sc_hd__tapvpwrvgnd_1
X_3163_ _2096_ VGND VGND VPWR VPWR _0278_ sky130_fd_sc_hd__clkbuf_2
X_3094_ _1996_ _1897_ _1820_ VGND VGND VPWR VPWR _0210_ sky130_fd_sc_hd__and3_1
XFILLER_0_55_97 VPWR VGND VPWR VGND sky130_ef_sc_hd__decap_12
XFILLER_0_76_268 VGND VGND VPWR VPWR sky130_fd_sc_hd__fill_1
XFILLER_0_71_63 VGND VGND VPWR VPWR sky130_fd_sc_hd__fill_1
X_3996_ _0998_ _1084_ _0997_ VGND VGND VPWR VPWR _1129_ sky130_fd_sc_hd__a21bo_1
X_2947_ _2050_ _2049_ _2121_ VGND VGND VPWR VPWR _2122_ sky130_fd_sc_hd__nand3_1
XFILLER_0_17_357 VPWR VGND VPWR VGND sky130_ef_sc_hd__decap_12
XFILLER_0_4_251 VGND VGND VPWR VPWR sky130_fd_sc_hd__fill_1
X_2878_ _1989_ _1993_ _2052_ _1691_ VGND VGND VPWR VPWR _2054_ sky130_fd_sc_hd__o31ai_1
XTAP_791 VGND VPWR sky130_fd_sc_hd__tapvpwrvgnd_1
XTAP_780 VGND VPWR sky130_fd_sc_hd__tapvpwrvgnd_1
XFILLER_0_67_213 VGND VGND VPWR VPWR sky130_fd_sc_hd__decap_8
XFILLER_0_67_279 VGND VGND VPWR VPWR sky130_fd_sc_hd__fill_1
XFILLER_0_35_121 VGND VGND VPWR VPWR sky130_fd_sc_hd__decap_3
XFILLER_0_63_441 VGND VGND VPWR VPWR sky130_fd_sc_hd__decap_6
X_3850_ _0969_ _0958_ _0959_ VGND VGND VPWR VPWR _0971_ sky130_fd_sc_hd__or3_4
X_3781_ _0884_ _0885_ _0895_ VGND VGND VPWR VPWR _0896_ sky130_fd_sc_hd__o21a_1
X_2801_ _1969_ _1970_ _1977_ VGND VGND VPWR VPWR _1978_ sky130_fd_sc_hd__a21o_1
XFILLER_0_73_249 VGND VGND VPWR VPWR sky130_fd_sc_hd__fill_1
X_2732_ _1851_ _1852_ _1908_ _1909_ VGND VGND VPWR VPWR _1910_ sky130_fd_sc_hd__a211oi_1
X_2663_ _1721_ VGND VGND VPWR VPWR _1842_ sky130_fd_sc_hd__clkbuf_2
XFILLER_0_41_157 VGND VGND VPWR VPWR sky130_fd_sc_hd__decap_4
XFILLER_0_1_232 VGND VGND VPWR VPWR sky130_fd_sc_hd__fill_2
XFILLER_0_1_221 VGND VGND VPWR VPWR sky130_fd_sc_hd__decap_3
X_2594_ net15 VGND VGND VPWR VPWR _1774_ sky130_fd_sc_hd__buf_2
XFILLER_0_1_265 VGND VGND VPWR VPWR sky130_fd_sc_hd__decap_3
XFILLER_0_5_33 VPWR VGND VPWR VGND sky130_ef_sc_hd__decap_12
XFILLER_0_1_287 VGND VGND VPWR VPWR sky130_fd_sc_hd__decap_8
X_4264_ clknet_3_7__leaf_clk _0009_ net35 VGND VGND VPWR VPWR net69 sky130_fd_sc_hd__dfrtp_4
X_3215_ net25 VGND VGND VPWR VPWR _0329_ sky130_fd_sc_hd__clkbuf_2
XFILLER_0_66_52 VGND VGND VPWR VPWR sky130_fd_sc_hd__decap_3
X_4195_ _1342_ _1343_ VGND VGND VPWR VPWR _1344_ sky130_fd_sc_hd__and2b_1
XFILLER_0_5_99 VPWR VGND VPWR VGND sky130_ef_sc_hd__decap_12
XFILLER_0_66_85 VGND VGND VPWR VPWR sky130_fd_sc_hd__decap_4
X_3146_ _0163_ _0172_ _0260_ VGND VGND VPWR VPWR _0261_ sky130_fd_sc_hd__a21oi_1
X_3077_ _0192_ _1939_ _2016_ _1706_ VGND VGND VPWR VPWR _0193_ sky130_fd_sc_hd__a22oi_1
XFILLER_0_64_216 VGND VGND VPWR VPWR sky130_fd_sc_hd__decap_8
X_3979_ _1043_ _1045_ _1110_ VGND VGND VPWR VPWR _1111_ sky130_fd_sc_hd__o21ba_1
XFILLER_0_45_441 VGND VGND VPWR VPWR sky130_fd_sc_hd__decap_6
XFILLER_0_32_135 VGND VGND VPWR VPWR sky130_fd_sc_hd__decap_4
XFILLER_0_13_360 VGND VGND VPWR VPWR sky130_fd_sc_hd__fill_2
XFILLER_0_13_393 VPWR VGND VPWR VGND sky130_ef_sc_hd__decap_12
XFILLER_0_55_238 VGND VGND VPWR VPWR sky130_fd_sc_hd__fill_2
XFILLER_0_51_422 VGND VGND VPWR VPWR sky130_fd_sc_hd__fill_1
XFILLER_0_36_11 VGND VGND VPWR VPWR sky130_fd_sc_hd__fill_2
Xinput7 in_a[13] VGND VGND VPWR VPWR net7 sky130_fd_sc_hd__clkbuf_4
XFILLER_0_36_22 VGND VGND VPWR VPWR sky130_fd_sc_hd__decap_6
XFILLER_0_36_44 VPWR VGND VPWR VGND sky130_ef_sc_hd__decap_12
X_3000_ _1725_ VGND VGND VPWR VPWR _0117_ sky130_fd_sc_hd__buf_4
X_3902_ _0919_ _0927_ _1024_ _1025_ VGND VGND VPWR VPWR _1028_ sky130_fd_sc_hd__a211oi_2
XFILLER_0_19_419 VGND VGND VPWR VPWR sky130_fd_sc_hd__decap_4
X_3833_ _0952_ _0878_ VGND VGND VPWR VPWR _0953_ sky130_fd_sc_hd__nand2_1
X_3764_ _0871_ _0872_ _0876_ VGND VGND VPWR VPWR _0878_ sky130_fd_sc_hd__nand3_2
XFILLER_0_6_357 VGND VGND VPWR VPWR sky130_fd_sc_hd__decap_6
X_2715_ _1679_ _1892_ _1845_ _1844_ VGND VGND VPWR VPWR _1893_ sky130_fd_sc_hd__a31o_1
XFILLER_0_54_293 VGND VGND VPWR VPWR sky130_fd_sc_hd__decap_4
X_3695_ _0801_ _0803_ VGND VGND VPWR VPWR _0804_ sky130_fd_sc_hd__xnor2_1
X_2646_ net14 VGND VGND VPWR VPWR _1825_ sky130_fd_sc_hd__clkbuf_2
XFILLER_0_10_363 VGND VGND VPWR VPWR sky130_fd_sc_hd__fill_1
X_2577_ _1756_ _1757_ net3 net30 VGND VGND VPWR VPWR _1758_ sky130_fd_sc_hd__and4bb_1
XFILLER_0_58_3 VPWR VGND VPWR VGND sky130_ef_sc_hd__decap_12
X_4316_ clknet_3_4__leaf_clk _0061_ net35 VGND VGND VPWR VPWR add_tmp\[23\] sky130_fd_sc_hd__dfrtp_2
X_4247_ _1367_ _1369_ _1346_ VGND VGND VPWR VPWR _1399_ sky130_fd_sc_hd__or3b_1
X_4178_ _1226_ _1272_ _1271_ VGND VGND VPWR VPWR _1326_ sky130_fd_sc_hd__a21oi_1
X_3129_ _1661_ net24 _0241_ _0243_ VGND VGND VPWR VPWR _0244_ sky130_fd_sc_hd__and4_1
XFILLER_0_77_385 VGND VGND VPWR VPWR sky130_fd_sc_hd__decap_6
XFILLER_0_33_422 VGND VGND VPWR VPWR sky130_fd_sc_hd__decap_8
XFILLER_0_60_274 VGND VGND VPWR VPWR sky130_fd_sc_hd__decap_3
XPHY_80 VGND VGND VPWR VPWR sky130_fd_sc_hd__decap_3
XPHY_91 VGND VGND VPWR VPWR sky130_fd_sc_hd__decap_3
XFILLER_0_3_305 VPWR VGND VPWR VGND sky130_ef_sc_hd__decap_12
XFILLER_0_51_230 VGND VGND VPWR VPWR sky130_fd_sc_hd__fill_1
X_3480_ _0589_ _0590_ _0501_ _0503_ VGND VGND VPWR VPWR _0592_ sky130_fd_sc_hd__a211oi_1
XFILLER_0_3_349 VGND VGND VPWR VPWR sky130_fd_sc_hd__fill_2
X_2500_ _1682_ _1683_ VGND VGND VPWR VPWR _1684_ sky130_fd_sc_hd__nor2_1
XFILLER_0_51_252 VGND VGND VPWR VPWR sky130_fd_sc_hd__decap_3
X_2431_ _1467_ _1620_ VGND VGND VPWR VPWR _1624_ sky130_fd_sc_hd__nand2_1
X_2362_ _0897_ _1567_ VGND VGND VPWR VPWR _1568_ sky130_fd_sc_hd__xnor2_1
X_4101_ _1196_ _1235_ VGND VGND VPWR VPWR _1242_ sky130_fd_sc_hd__or2b_1
X_2293_ _1179_ _1510_ _1168_ VGND VGND VPWR VPWR _1512_ sky130_fd_sc_hd__and3_1
X_4032_ _1165_ _1167_ _1095_ _1106_ VGND VGND VPWR VPWR _1169_ sky130_fd_sc_hd__a211oi_2
XFILLER_0_47_98 VGND VGND VPWR VPWR sky130_fd_sc_hd__decap_8
XFILLER_0_63_75 VGND VGND VPWR VPWR sky130_fd_sc_hd__decap_6
XFILLER_0_59_374 VPWR VGND VPWR VGND sky130_ef_sc_hd__decap_12
XFILLER_0_63_86 VPWR VGND VPWR VGND sky130_ef_sc_hd__decap_12
XFILLER_0_74_344 VGND VGND VPWR VPWR sky130_fd_sc_hd__fill_1
XFILLER_0_15_400 VPWR VGND VPWR VGND sky130_ef_sc_hd__decap_12
X_3816_ _1799_ _1821_ _0859_ VGND VGND VPWR VPWR _0934_ sky130_fd_sc_hd__nand3_2
XFILLER_0_27_271 VGND VGND VPWR VPWR sky130_fd_sc_hd__decap_3
X_3747_ _0331_ VGND VGND VPWR VPWR _0859_ sky130_fd_sc_hd__dlymetal6s2s_1
XFILLER_0_30_403 VGND VGND VPWR VPWR sky130_fd_sc_hd__decap_8
X_3678_ _0784_ _0785_ _0786_ VGND VGND VPWR VPWR _0787_ sky130_fd_sc_hd__a21oi_1
X_2629_ _1806_ VGND VGND VPWR VPWR _1809_ sky130_fd_sc_hd__buf_6
XTAP_609 VGND VPWR sky130_fd_sc_hd__tapvpwrvgnd_1
XFILLER_0_17_57 VGND VGND VPWR VPWR sky130_fd_sc_hd__decap_4
XFILLER_0_33_34 VGND VGND VPWR VPWR sky130_fd_sc_hd__fill_2
X_2980_ _2078_ _2080_ VGND VGND VPWR VPWR _0097_ sky130_fd_sc_hd__and2_1
XFILLER_0_68_182 VGND VGND VPWR VPWR sky130_fd_sc_hd__decap_6
Xinput10 in_a[1] VGND VGND VPWR VPWR net10 sky130_fd_sc_hd__buf_2
X_3601_ _1837_ _0326_ _0708_ _0709_ VGND VGND VPWR VPWR _0711_ sky130_fd_sc_hd__nand4_4
Xinput21 in_b[11] VGND VGND VPWR VPWR net21 sky130_fd_sc_hd__buf_1
Xinput32 in_b[7] VGND VGND VPWR VPWR net32 sky130_fd_sc_hd__buf_4
XFILLER_0_12_403 VGND VGND VPWR VPWR sky130_fd_sc_hd__fill_1
X_3532_ _0641_ _0639_ _0640_ VGND VGND VPWR VPWR _0643_ sky130_fd_sc_hd__nand3_1
X_3463_ _0567_ _0568_ _0574_ VGND VGND VPWR VPWR _0575_ sky130_fd_sc_hd__a21o_1
X_2414_ _1508_ _1609_ _1610_ VGND VGND VPWR VPWR _0027_ sky130_fd_sc_hd__a21o_1
X_3394_ _0505_ _0506_ VGND VGND VPWR VPWR _0507_ sky130_fd_sc_hd__or2_1
X_2345_ _1554_ VGND VGND VPWR VPWR _0014_ sky130_fd_sc_hd__clkbuf_1
X_2276_ _1135_ _1114_ _1124_ VGND VGND VPWR VPWR _1497_ sky130_fd_sc_hd__nand3_1
XFILLER_0_74_41 VPWR VGND VPWR VGND sky130_ef_sc_hd__decap_12
X_4015_ _1138_ _1149_ VGND VGND VPWR VPWR _1150_ sky130_fd_sc_hd__xnor2_1
XFILLER_0_74_85 VPWR VGND VPWR VGND sky130_ef_sc_hd__decap_12
XFILLER_0_74_141 VGND VGND VPWR VPWR sky130_fd_sc_hd__decap_4
XFILLER_0_47_366 VGND VGND VPWR VPWR sky130_fd_sc_hd__fill_1
XFILLER_0_62_347 VGND VGND VPWR VPWR sky130_fd_sc_hd__decap_6
XFILLER_0_74_185 VGND VGND VPWR VPWR sky130_fd_sc_hd__fill_1
XFILLER_0_70_380 VGND VGND VPWR VPWR sky130_fd_sc_hd__decap_8
XFILLER_0_30_299 VGND VGND VPWR VPWR sky130_fd_sc_hd__fill_1
XFILLER_0_38_344 VGND VGND VPWR VPWR sky130_fd_sc_hd__decap_4
XFILLER_0_0_149 VPWR VGND VPWR VGND sky130_ef_sc_hd__decap_12
XTAP_406 VGND VPWR sky130_fd_sc_hd__tapvpwrvgnd_1
XTAP_417 VGND VPWR sky130_fd_sc_hd__tapvpwrvgnd_1
XTAP_428 VGND VPWR sky130_fd_sc_hd__tapvpwrvgnd_1
XTAP_439 VGND VPWR sky130_fd_sc_hd__tapvpwrvgnd_1
XFILLER_0_28_45 VPWR VGND VPWR VGND sky130_ef_sc_hd__decap_12
X_2130_ net63 _0842_ VGND VGND VPWR VPWR _0853_ sky130_fd_sc_hd__or2_1
XFILLER_0_28_89 VGND VGND VPWR VPWR sky130_fd_sc_hd__fill_1
X_2963_ _0079_ VGND VGND VPWR VPWR _0080_ sky130_fd_sc_hd__dlymetal6s2s_1
XFILLER_0_56_141 VPWR VGND VPWR VGND sky130_ef_sc_hd__decap_12
XFILLER_0_60_21 VGND VGND VPWR VPWR sky130_fd_sc_hd__decap_6
XFILLER_0_44_303 VGND VGND VPWR VPWR sky130_fd_sc_hd__decap_4
X_2894_ _2039_ _2067_ VGND VGND VPWR VPWR _2069_ sky130_fd_sc_hd__nor2_1
XFILLER_0_4_433 VPWR VGND VPWR VGND sky130_ef_sc_hd__decap_12
XFILLER_0_71_166 VGND VGND VPWR VPWR sky130_fd_sc_hd__fill_2
XFILLER_0_12_200 VGND VGND VPWR VPWR sky130_fd_sc_hd__fill_1
XFILLER_0_52_380 VPWR VGND VPWR VGND sky130_ef_sc_hd__decap_12
XFILLER_0_8_88 VGND VGND VPWR VPWR sky130_fd_sc_hd__decap_8
X_3515_ _0608_ _0625_ VGND VGND VPWR VPWR _0626_ sky130_fd_sc_hd__xor2_2
XFILLER_0_12_266 VGND VGND VPWR VPWR sky130_fd_sc_hd__fill_1
X_3446_ _0555_ _0556_ _0528_ _0456_ VGND VGND VPWR VPWR _0558_ sky130_fd_sc_hd__a211o_1
XFILLER_0_40_3 VPWR VGND VPWR VGND sky130_ef_sc_hd__decap_12
X_3377_ _0400_ _0404_ _0399_ VGND VGND VPWR VPWR _0490_ sky130_fd_sc_hd__a21o_1
X_2328_ _1297_ _1539_ _1540_ VGND VGND VPWR VPWR _1541_ sky130_fd_sc_hd__o21a_1
X_2259_ _0853_ _0864_ _1482_ VGND VGND VPWR VPWR _1483_ sky130_fd_sc_hd__mux2_1
XFILLER_0_39_119 VPWR VGND VPWR VGND sky130_ef_sc_hd__decap_12
XFILLER_0_47_130 VGND VGND VPWR VPWR sky130_fd_sc_hd__decap_4
XFILLER_0_75_461 VGND VGND VPWR VPWR sky130_fd_sc_hd__fill_2
XFILLER_0_47_141 VPWR VGND VPWR VGND sky130_ef_sc_hd__decap_12
XFILLER_0_35_325 VGND VGND VPWR VPWR sky130_fd_sc_hd__decap_3
XFILLER_0_7_293 VPWR VGND VPWR VGND sky130_ef_sc_hd__decap_12
XFILLER_0_43_391 VGND VGND VPWR VPWR sky130_fd_sc_hd__fill_1
XFILLER_0_14_47 VGND VGND VPWR VPWR sky130_fd_sc_hd__decap_6
XFILLER_0_38_141 VGND VGND VPWR VPWR sky130_fd_sc_hd__decap_6
XFILLER_0_53_111 VGND VGND VPWR VPWR sky130_fd_sc_hd__fill_1
XFILLER_0_1_447 VGND VGND VPWR VPWR sky130_fd_sc_hd__fill_1
XFILLER_0_39_22 VPWR VGND VPWR VGND sky130_ef_sc_hd__decap_12
X_3300_ _0411_ _0412_ _0324_ VGND VGND VPWR VPWR _0414_ sky130_fd_sc_hd__a21o_1
XTAP_214 VGND VPWR sky130_fd_sc_hd__tapvpwrvgnd_1
XTAP_203 VGND VPWR sky130_fd_sc_hd__tapvpwrvgnd_1
X_4280_ clknet_3_5__leaf_clk _0025_ net35 VGND VGND VPWR VPWR net51 sky130_fd_sc_hd__dfrtp_2
XTAP_247 VGND VPWR sky130_fd_sc_hd__tapvpwrvgnd_1
XTAP_236 VGND VPWR sky130_fd_sc_hd__tapvpwrvgnd_1
XTAP_225 VGND VPWR sky130_fd_sc_hd__tapvpwrvgnd_1
X_3231_ _0343_ _0344_ VGND VGND VPWR VPWR _0345_ sky130_fd_sc_hd__nor2_1
XTAP_269 VGND VPWR sky130_fd_sc_hd__tapvpwrvgnd_1
XTAP_258 VGND VPWR sky130_fd_sc_hd__tapvpwrvgnd_1
X_3162_ _1940_ VGND VGND VPWR VPWR _0277_ sky130_fd_sc_hd__dlymetal6s2s_1
X_3093_ _2007_ _0208_ VGND VGND VPWR VPWR _0209_ sky130_fd_sc_hd__nand2_1
XFILLER_0_55_76 VPWR VGND VPWR VGND sky130_ef_sc_hd__decap_12
XFILLER_0_71_31 VGND VGND VPWR VPWR sky130_fd_sc_hd__decap_6
X_3995_ _1067_ _1076_ _1075_ VGND VGND VPWR VPWR _1128_ sky130_fd_sc_hd__a21bo_1
XFILLER_0_57_461 VGND VGND VPWR VPWR sky130_fd_sc_hd__fill_2
X_2946_ _2119_ _2120_ VGND VGND VPWR VPWR _2121_ sky130_fd_sc_hd__nor2_2
XFILLER_0_17_369 VGND VGND VPWR VPWR sky130_fd_sc_hd__decap_6
XFILLER_0_44_133 VGND VGND VPWR VPWR sky130_fd_sc_hd__decap_6
X_2877_ _1989_ _1993_ _2052_ VGND VGND VPWR VPWR _2053_ sky130_fd_sc_hd__o21a_1
XFILLER_0_32_317 VGND VGND VPWR VPWR sky130_fd_sc_hd__decap_3
XFILLER_0_4_285 VGND VGND VPWR VPWR sky130_fd_sc_hd__fill_1
XFILLER_0_25_391 VGND VGND VPWR VPWR sky130_fd_sc_hd__fill_1
XFILLER_0_40_372 VPWR VGND VPWR VGND sky130_ef_sc_hd__decap_12
X_3429_ _0539_ _0529_ _0533_ VGND VGND VPWR VPWR _0541_ sky130_fd_sc_hd__nand3_1
XTAP_770 VGND VPWR sky130_fd_sc_hd__tapvpwrvgnd_1
XTAP_792 VGND VPWR sky130_fd_sc_hd__tapvpwrvgnd_1
XTAP_781 VGND VPWR sky130_fd_sc_hd__tapvpwrvgnd_1
XFILLER_0_67_225 VGND VGND VPWR VPWR sky130_fd_sc_hd__decap_6
XFILLER_0_63_453 VGND VGND VPWR VPWR sky130_fd_sc_hd__fill_1
XFILLER_0_73_217 VGND VGND VPWR VPWR sky130_fd_sc_hd__decap_4
X_3780_ _0745_ _0894_ VGND VGND VPWR VPWR _0895_ sky130_fd_sc_hd__xnor2_2
X_2800_ _1972_ _1976_ VGND VGND VPWR VPWR _1977_ sky130_fd_sc_hd__xnor2_1
XFILLER_0_41_45 VGND VGND VPWR VPWR sky130_fd_sc_hd__fill_2
X_2731_ _1907_ _1889_ _1890_ VGND VGND VPWR VPWR _1909_ sky130_fd_sc_hd__nor3_4
X_2662_ _1754_ VGND VGND VPWR VPWR _1841_ sky130_fd_sc_hd__clkbuf_2
X_2593_ _1726_ net14 net15 _1723_ VGND VGND VPWR VPWR _1773_ sky130_fd_sc_hd__a22o_1
XFILLER_0_5_45 VGND VGND VPWR VPWR sky130_fd_sc_hd__decap_8
X_4263_ clknet_3_3__leaf_clk _0008_ net35 VGND VGND VPWR VPWR net68 sky130_fd_sc_hd__dfrtp_4
X_3214_ net9 VGND VGND VPWR VPWR _0328_ sky130_fd_sc_hd__dlymetal6s2s_1
X_4194_ _1303_ _1300_ _1341_ VGND VGND VPWR VPWR _1343_ sky130_fd_sc_hd__o21ai_1
X_3145_ _0170_ _0171_ VGND VGND VPWR VPWR _0260_ sky130_fd_sc_hd__and2_1
X_3076_ _1754_ VGND VGND VPWR VPWR _0192_ sky130_fd_sc_hd__buf_6
XFILLER_0_49_214 VGND VGND VPWR VPWR sky130_fd_sc_hd__decap_4
XFILLER_0_9_300 VPWR VGND VPWR VGND sky130_ef_sc_hd__decap_12
XFILLER_0_49_269 VGND VGND VPWR VPWR sky130_fd_sc_hd__decap_6
XFILLER_0_17_111 VGND VGND VPWR VPWR sky130_fd_sc_hd__fill_1
X_3978_ _1057_ _1109_ VGND VGND VPWR VPWR _1110_ sky130_fd_sc_hd__xor2_1
X_2929_ _2101_ _2102_ _2090_ VGND VGND VPWR VPWR _2104_ sky130_fd_sc_hd__a21o_1
XFILLER_0_72_250 VGND VGND VPWR VPWR sky130_fd_sc_hd__fill_2
XFILLER_0_20_309 VGND VGND VPWR VPWR sky130_fd_sc_hd__decap_6
XFILLER_0_11_15 VGND VGND VPWR VPWR sky130_fd_sc_hd__decap_6
XFILLER_0_36_442 VGND VGND VPWR VPWR sky130_fd_sc_hd__fill_1
XFILLER_0_11_48 VGND VGND VPWR VPWR sky130_fd_sc_hd__fill_1
XFILLER_0_63_294 VGND VGND VPWR VPWR sky130_fd_sc_hd__decap_6
XFILLER_0_23_169 VGND VGND VPWR VPWR sky130_fd_sc_hd__decap_8
Xinput8 in_a[14] VGND VGND VPWR VPWR net8 sky130_fd_sc_hd__buf_1
XFILLER_0_36_56 VGND VGND VPWR VPWR sky130_fd_sc_hd__decap_4
X_3901_ _1024_ _1025_ _0919_ _0927_ VGND VGND VPWR VPWR _1026_ sky130_fd_sc_hd__o211a_1
XFILLER_0_52_44 VPWR VGND VPWR VGND sky130_ef_sc_hd__decap_12
X_3832_ _0950_ VGND VGND VPWR VPWR _0952_ sky130_fd_sc_hd__dlymetal6s2s_1
XFILLER_0_27_420 VGND VGND VPWR VPWR sky130_fd_sc_hd__decap_8
XFILLER_0_52_77 VGND VGND VPWR VPWR sky130_fd_sc_hd__decap_6
X_3763_ _0871_ _0872_ _0876_ VGND VGND VPWR VPWR _0877_ sky130_fd_sc_hd__a21o_1
XFILLER_0_6_347 VGND VGND VPWR VPWR sky130_fd_sc_hd__decap_6
X_2714_ _1759_ VGND VGND VPWR VPWR _1892_ sky130_fd_sc_hd__clkbuf_2
X_3694_ _0697_ _0722_ _0802_ VGND VGND VPWR VPWR _0803_ sky130_fd_sc_hd__a21oi_1
XFILLER_0_14_169 VGND VGND VPWR VPWR sky130_fd_sc_hd__fill_2
X_2645_ _1815_ _1823_ VGND VGND VPWR VPWR _1824_ sky130_fd_sc_hd__xnor2_1
XFILLER_0_77_63 VPWR VGND VPWR VGND sky130_ef_sc_hd__decap_12
X_4315_ clknet_3_4__leaf_clk _0060_ net35 VGND VGND VPWR VPWR add_tmp\[22\] sky130_fd_sc_hd__dfrtp_1
X_2576_ net10 _1729_ net28 _1754_ VGND VGND VPWR VPWR _1757_ sky130_fd_sc_hd__and4_1
XFILLER_0_77_85 VPWR VGND VPWR VGND sky130_ef_sc_hd__decap_12
XFILLER_0_10_386 VGND VGND VPWR VPWR sky130_fd_sc_hd__fill_1
X_4246_ _1396_ _1397_ VGND VGND VPWR VPWR _1398_ sky130_fd_sc_hd__xnor2_1
X_4177_ _1228_ _1180_ _1273_ VGND VGND VPWR VPWR _1325_ sky130_fd_sc_hd__or3_1
X_3128_ _0242_ VGND VGND VPWR VPWR _0243_ sky130_fd_sc_hd__inv_2
X_3059_ _0153_ _0154_ _0173_ VGND VGND VPWR VPWR _0175_ sky130_fd_sc_hd__and3_1
XFILLER_0_5_391 VGND VGND VPWR VPWR sky130_fd_sc_hd__fill_1
XFILLER_0_60_253 VGND VGND VPWR VPWR sky130_fd_sc_hd__fill_2
XFILLER_0_20_128 VGND VGND VPWR VPWR sky130_fd_sc_hd__fill_1
XFILLER_0_20_139 VGND VGND VPWR VPWR sky130_fd_sc_hd__fill_1
XFILLER_0_68_320 VPWR VGND VPWR VGND sky130_ef_sc_hd__decap_12
XFILLER_0_68_342 VPWR VGND VPWR VGND sky130_ef_sc_hd__decap_12
XPHY_70 VGND VGND VPWR VPWR sky130_fd_sc_hd__decap_3
XPHY_81 VGND VGND VPWR VPWR sky130_fd_sc_hd__decap_3
XPHY_92 VGND VGND VPWR VPWR sky130_fd_sc_hd__decap_3
XFILLER_0_36_261 VGND VGND VPWR VPWR sky130_fd_sc_hd__fill_1
XFILLER_0_3_317 VGND VGND VPWR VPWR sky130_fd_sc_hd__decap_4
X_2430_ _1623_ VGND VGND VPWR VPWR _0030_ sky130_fd_sc_hd__clkbuf_1
X_2361_ _0908_ _1393_ VGND VGND VPWR VPWR _1567_ sky130_fd_sc_hd__nor2_1
X_4100_ _1239_ _1240_ VGND VGND VPWR VPWR _1241_ sky130_fd_sc_hd__xnor2_1
X_2292_ _1179_ _1510_ _1168_ VGND VGND VPWR VPWR _1511_ sky130_fd_sc_hd__a21oi_1
XFILLER_0_47_55 VGND VGND VPWR VPWR sky130_fd_sc_hd__fill_1
X_4031_ _1166_ VGND VGND VPWR VPWR _1167_ sky130_fd_sc_hd__inv_2
XFILLER_0_59_320 VPWR VGND VPWR VGND sky130_ef_sc_hd__decap_12
XFILLER_0_63_65 VGND VGND VPWR VPWR sky130_fd_sc_hd__decap_3
XFILLER_0_63_98 VPWR VGND VPWR VGND sky130_ef_sc_hd__decap_12
XFILLER_0_59_386 VGND VGND VPWR VPWR sky130_fd_sc_hd__decap_6
XFILLER_0_74_378 VGND VGND VPWR VPWR sky130_fd_sc_hd__fill_1
X_3815_ _0931_ _0928_ _0930_ VGND VGND VPWR VPWR _0933_ sky130_fd_sc_hd__nand3_1
XFILLER_0_15_445 VGND VGND VPWR VPWR sky130_fd_sc_hd__decap_3
X_3746_ _0857_ VGND VGND VPWR VPWR _0858_ sky130_fd_sc_hd__clkbuf_2
XFILLER_0_42_253 VGND VGND VPWR VPWR sky130_fd_sc_hd__decap_8
X_3677_ _0700_ _0701_ VGND VGND VPWR VPWR _0786_ sky130_fd_sc_hd__nand2_1
XFILLER_0_70_3 VPWR VGND VPWR VGND sky130_ef_sc_hd__decap_12
X_2628_ _1738_ _1768_ _1806_ _1807_ VGND VGND VPWR VPWR _1808_ sky130_fd_sc_hd__nor4_4
X_2559_ _1710_ _1738_ _1739_ VGND VGND VPWR VPWR _1741_ sky130_fd_sc_hd__nand3_1
X_4229_ _1378_ _1379_ VGND VGND VPWR VPWR _1380_ sky130_fd_sc_hd__or2_1
XFILLER_0_69_139 VGND VGND VPWR VPWR sky130_fd_sc_hd__decap_6
XFILLER_0_77_161 VGND VGND VPWR VPWR sky130_fd_sc_hd__decap_6
XFILLER_0_65_345 VGND VGND VPWR VPWR sky130_fd_sc_hd__decap_3
XFILLER_0_33_220 VGND VGND VPWR VPWR sky130_fd_sc_hd__decap_4
XFILLER_0_21_437 VGND VGND VPWR VPWR sky130_fd_sc_hd__decap_3
XFILLER_0_68_194 VGND VGND VPWR VPWR sky130_fd_sc_hd__fill_2
Xinput22 in_b[12] VGND VGND VPWR VPWR net22 sky130_fd_sc_hd__clkbuf_2
Xinput11 in_a[2] VGND VGND VPWR VPWR net11 sky130_fd_sc_hd__buf_2
X_3600_ _1787_ _0326_ _0708_ _0709_ VGND VGND VPWR VPWR _0710_ sky130_fd_sc_hd__a22o_1
XFILLER_0_71_337 VPWR VGND VPWR VGND sky130_ef_sc_hd__decap_12
Xinput33 in_b[8] VGND VGND VPWR VPWR net33 sky130_fd_sc_hd__clkbuf_2
X_3531_ _0639_ _0640_ _0641_ VGND VGND VPWR VPWR _0642_ sky130_fd_sc_hd__a21o_1
XFILLER_0_3_136 VGND VGND VPWR VPWR sky130_fd_sc_hd__decap_4
XFILLER_0_3_147 VPWR VGND VPWR VGND sky130_ef_sc_hd__decap_12
XFILLER_0_3_169 VGND VGND VPWR VPWR sky130_fd_sc_hd__decap_8
X_3462_ _0572_ _0573_ VGND VGND VPWR VPWR _0574_ sky130_fd_sc_hd__xnor2_1
X_2413_ net53 _1580_ _1581_ add_tmp\[25\] VGND VGND VPWR VPWR _1610_ sky130_fd_sc_hd__a22o_1
X_3393_ _0503_ _0504_ _0411_ _0413_ VGND VGND VPWR VPWR _0506_ sky130_fd_sc_hd__o211a_1
X_2344_ net39 _1552_ _1553_ VGND VGND VPWR VPWR _1554_ sky130_fd_sc_hd__mux2_1
X_2275_ _1494_ _1496_ VGND VGND VPWR VPWR _0002_ sky130_fd_sc_hd__xor2_1
X_4014_ _1147_ _1148_ VGND VGND VPWR VPWR _1149_ sky130_fd_sc_hd__or2b_1
XFILLER_0_74_53 VPWR VGND VPWR VGND sky130_ef_sc_hd__decap_12
XFILLER_0_74_97 VGND VGND VPWR VPWR sky130_fd_sc_hd__fill_1
XFILLER_0_47_301 VGND VGND VPWR VPWR sky130_fd_sc_hd__fill_2
XFILLER_0_74_153 VGND VGND VPWR VPWR sky130_fd_sc_hd__decap_8
X_3729_ _0759_ _0760_ _0836_ _0838_ VGND VGND VPWR VPWR _0839_ sky130_fd_sc_hd__a211o_1
XFILLER_0_30_201 VGND VGND VPWR VPWR sky130_fd_sc_hd__decap_6
XFILLER_0_30_245 VGND VGND VPWR VPWR sky130_fd_sc_hd__decap_6
XFILLER_0_65_164 VGND VGND VPWR VPWR sky130_fd_sc_hd__decap_4
XFILLER_0_0_139 VGND VGND VPWR VPWR sky130_fd_sc_hd__fill_1
XTAP_407 VGND VPWR sky130_fd_sc_hd__tapvpwrvgnd_1
XTAP_418 VGND VPWR sky130_fd_sc_hd__tapvpwrvgnd_1
XTAP_429 VGND VPWR sky130_fd_sc_hd__tapvpwrvgnd_1
XFILLER_0_28_57 VPWR VGND VPWR VGND sky130_ef_sc_hd__decap_12
XFILLER_0_44_45 VPWR VGND VPWR VGND sky130_ef_sc_hd__decap_12
X_2962_ _0078_ VGND VGND VPWR VPWR _0079_ sky130_fd_sc_hd__dlymetal6s2s_1
XFILLER_0_29_389 VGND VGND VPWR VPWR sky130_fd_sc_hd__decap_3
XFILLER_0_44_315 VGND VGND VPWR VPWR sky130_fd_sc_hd__fill_1
XFILLER_0_56_153 VGND VGND VPWR VPWR sky130_fd_sc_hd__decap_8
X_2893_ _2039_ _2067_ VGND VGND VPWR VPWR _2068_ sky130_fd_sc_hd__and2_1
XFILLER_0_71_145 VGND VGND VPWR VPWR sky130_fd_sc_hd__fill_1
XFILLER_0_4_445 VPWR VGND VPWR VGND sky130_ef_sc_hd__decap_12
XFILLER_0_52_392 VPWR VGND VPWR VGND sky130_ef_sc_hd__decap_12
X_3514_ _0623_ _0624_ VGND VGND VPWR VPWR _0625_ sky130_fd_sc_hd__and2_1
X_3445_ _0528_ _0456_ _0555_ _0556_ VGND VGND VPWR VPWR _0557_ sky130_fd_sc_hd__o211ai_2
X_3376_ _0486_ _0487_ _0365_ _0395_ VGND VGND VPWR VPWR _0489_ sky130_fd_sc_hd__a211o_1
X_2327_ _1297_ _1539_ _1485_ VGND VGND VPWR VPWR _1540_ sky130_fd_sc_hd__a21oi_1
X_2258_ _1478_ _1479_ _1480_ _1481_ VGND VGND VPWR VPWR _1482_ sky130_fd_sc_hd__a211oi_2
XFILLER_0_33_3 VPWR VGND VPWR VGND sky130_ef_sc_hd__decap_12
X_2189_ _1411_ _1412_ VGND VGND VPWR VPWR _1413_ sky130_fd_sc_hd__nand2_1
XFILLER_0_47_120 VGND VGND VPWR VPWR sky130_fd_sc_hd__fill_2
XFILLER_0_47_153 VPWR VGND VPWR VGND sky130_ef_sc_hd__decap_12
XFILLER_0_35_337 VGND VGND VPWR VPWR sky130_fd_sc_hd__decap_4
XFILLER_0_50_307 VGND VGND VPWR VPWR sky130_fd_sc_hd__fill_1
XFILLER_0_58_418 VGND VGND VPWR VPWR sky130_fd_sc_hd__fill_2
XFILLER_0_38_120 VGND VGND VPWR VPWR sky130_fd_sc_hd__fill_1
XFILLER_0_38_131 VGND VGND VPWR VPWR sky130_fd_sc_hd__decap_4
XFILLER_0_30_25 VGND VGND VPWR VPWR sky130_fd_sc_hd__decap_3
XFILLER_0_53_134 VGND VGND VPWR VPWR sky130_fd_sc_hd__decap_3
XFILLER_0_53_167 VGND VGND VPWR VPWR sky130_fd_sc_hd__fill_1
XTAP_215 VGND VPWR sky130_fd_sc_hd__tapvpwrvgnd_1
XTAP_204 VGND VPWR sky130_fd_sc_hd__tapvpwrvgnd_1
XFILLER_0_39_34 VPWR VGND VPWR VGND sky130_ef_sc_hd__decap_12
XTAP_248 VGND VPWR sky130_fd_sc_hd__tapvpwrvgnd_1
XTAP_237 VGND VPWR sky130_fd_sc_hd__tapvpwrvgnd_1
XTAP_226 VGND VPWR sky130_fd_sc_hd__tapvpwrvgnd_1
X_3230_ _1934_ _1881_ _0270_ _0183_ VGND VGND VPWR VPWR _0344_ sky130_fd_sc_hd__and4_1
XTAP_259 VGND VPWR sky130_fd_sc_hd__tapvpwrvgnd_1
XFILLER_0_55_11 VGND VGND VPWR VPWR sky130_fd_sc_hd__fill_1
X_3161_ _0272_ _0273_ _0274_ VGND VGND VPWR VPWR _0276_ sky130_fd_sc_hd__a21o_1
X_3092_ _1894_ VGND VGND VPWR VPWR _0208_ sky130_fd_sc_hd__clkbuf_2
XFILLER_0_49_429 VGND VGND VPWR VPWR sky130_fd_sc_hd__decap_6
XFILLER_0_76_259 VGND VGND VPWR VPWR sky130_fd_sc_hd__decap_6
X_3994_ _1125_ _1126_ VGND VGND VPWR VPWR _1127_ sky130_fd_sc_hd__or2_1
XFILLER_0_57_440 VGND VGND VPWR VPWR sky130_fd_sc_hd__decap_8
X_2945_ _2117_ _2118_ net103 _2055_ VGND VGND VPWR VPWR _2120_ sky130_fd_sc_hd__a211oi_1
XFILLER_0_72_432 VPWR VGND VPWR VGND sky130_ef_sc_hd__decap_12
X_2876_ _2049_ _2051_ VGND VGND VPWR VPWR _2052_ sky130_fd_sc_hd__xnor2_2
XFILLER_0_4_253 VGND VGND VPWR VPWR sky130_fd_sc_hd__decap_3
XFILLER_0_25_381 VGND VGND VPWR VPWR sky130_fd_sc_hd__fill_1
XFILLER_0_20_80 VGND VGND VPWR VPWR sky130_fd_sc_hd__decap_4
XFILLER_0_40_384 VGND VGND VPWR VPWR sky130_fd_sc_hd__decap_6
X_3428_ _0529_ _0533_ _0539_ VGND VGND VPWR VPWR _0540_ sky130_fd_sc_hd__a21o_1
X_3359_ _0204_ _0156_ _0471_ _1955_ VGND VGND VPWR VPWR _0472_ sky130_fd_sc_hd__a22oi_1
XTAP_760 VGND VPWR sky130_fd_sc_hd__tapvpwrvgnd_1
XTAP_793 VGND VPWR sky130_fd_sc_hd__tapvpwrvgnd_1
XTAP_782 VGND VPWR sky130_fd_sc_hd__tapvpwrvgnd_1
XTAP_771 VGND VPWR sky130_fd_sc_hd__tapvpwrvgnd_1
XFILLER_0_35_145 VGND VGND VPWR VPWR sky130_fd_sc_hd__decap_8
XFILLER_0_50_115 VGND VGND VPWR VPWR sky130_fd_sc_hd__fill_1
XFILLER_0_31_373 VPWR VGND VPWR VGND sky130_ef_sc_hd__decap_12
XFILLER_0_39_462 VGND VGND VPWR VPWR sky130_fd_sc_hd__fill_1
XFILLER_0_54_421 VGND VGND VPWR VPWR sky130_fd_sc_hd__fill_1
X_2730_ _1889_ _1890_ net81 VGND VGND VPWR VPWR _1908_ sky130_fd_sc_hd__o21a_1
XFILLER_0_14_307 VGND VGND VPWR VPWR sky130_fd_sc_hd__fill_1
X_2661_ _1722_ VGND VGND VPWR VPWR _1840_ sky130_fd_sc_hd__buf_6
X_2592_ _1765_ _1766_ _1718_ VGND VGND VPWR VPWR _1772_ sky130_fd_sc_hd__and3b_1
X_4262_ clknet_3_3__leaf_clk _0007_ net35 VGND VGND VPWR VPWR net67 sky130_fd_sc_hd__dfrtp_2
X_3213_ _0326_ VGND VGND VPWR VPWR _0327_ sky130_fd_sc_hd__clkbuf_2
X_4193_ _1303_ _1300_ _1341_ VGND VGND VPWR VPWR _1342_ sky130_fd_sc_hd__nor3_1
X_3144_ _0239_ _0240_ _0257_ VGND VGND VPWR VPWR _0259_ sky130_fd_sc_hd__nor3_2
X_3075_ _0111_ VGND VGND VPWR VPWR _0191_ sky130_fd_sc_hd__clkbuf_2
XFILLER_0_9_334 VGND VGND VPWR VPWR sky130_fd_sc_hd__fill_2
XFILLER_0_9_312 VGND VGND VPWR VPWR sky130_fd_sc_hd__decap_6
X_3977_ _1107_ _1108_ VGND VGND VPWR VPWR _1109_ sky130_fd_sc_hd__xor2_1
X_2928_ _2090_ _2101_ _2102_ VGND VGND VPWR VPWR _2103_ sky130_fd_sc_hd__nand3_1
X_2859_ net20 VGND VGND VPWR VPWR _2035_ sky130_fd_sc_hd__buf_4
XTAP_590 VGND VPWR sky130_fd_sc_hd__tapvpwrvgnd_1
XFILLER_0_55_207 VPWR VGND VPWR VGND sky130_ef_sc_hd__decap_12
XFILLER_0_51_413 VGND VGND VPWR VPWR sky130_fd_sc_hd__decap_4
Xinput9 in_a[15] VGND VGND VPWR VPWR net9 sky130_fd_sc_hd__clkbuf_4
X_3900_ _1022_ _1023_ _1008_ VGND VGND VPWR VPWR _1025_ sky130_fd_sc_hd__a21oi_1
XFILLER_0_52_56 VGND VGND VPWR VPWR sky130_fd_sc_hd__fill_1
X_3831_ _0529_ _0873_ VGND VGND VPWR VPWR _0950_ sky130_fd_sc_hd__or2_1
XFILLER_0_52_67 VGND VGND VPWR VPWR sky130_fd_sc_hd__decap_4
X_3762_ _0874_ VGND VGND VPWR VPWR _0876_ sky130_fd_sc_hd__clkbuf_2
XFILLER_0_27_432 VGND VGND VPWR VPWR sky130_fd_sc_hd__decap_4
XFILLER_0_42_413 VGND VGND VPWR VPWR sky130_fd_sc_hd__decap_3
X_2713_ _1822_ VGND VGND VPWR VPWR _1891_ sky130_fd_sc_hd__inv_2
X_3693_ _0719_ _0721_ VGND VGND VPWR VPWR _0802_ sky130_fd_sc_hd__nor2_1
X_2644_ _1819_ _1822_ VGND VGND VPWR VPWR _1823_ sky130_fd_sc_hd__nor2_1
X_2575_ _1752_ _1753_ _1755_ net10 VGND VGND VPWR VPWR _1756_ sky130_fd_sc_hd__a22oi_1
XFILLER_0_10_321 VGND VGND VPWR VPWR sky130_fd_sc_hd__fill_1
X_4314_ clknet_3_4__leaf_clk _0059_ net35 VGND VGND VPWR VPWR add_tmp\[21\] sky130_fd_sc_hd__dfrtp_1
XFILLER_0_77_97 VPWR VGND VPWR VGND sky130_ef_sc_hd__decap_12
XFILLER_0_77_75 VGND VGND VPWR VPWR sky130_fd_sc_hd__decap_4
XFILLER_0_10_376 VGND VGND VPWR VPWR sky130_fd_sc_hd__decap_4
XFILLER_0_10_365 VGND VGND VPWR VPWR sky130_fd_sc_hd__decap_6
X_4245_ _1373_ _1376_ _1379_ VGND VGND VPWR VPWR _1397_ sky130_fd_sc_hd__a21oi_1
X_4176_ _1323_ VGND VGND VPWR VPWR _1324_ sky130_fd_sc_hd__inv_2
X_3127_ _1666_ _1752_ net22 net23 VGND VGND VPWR VPWR _0242_ sky130_fd_sc_hd__and4_1
XFILLER_0_77_321 VPWR VGND VPWR VGND sky130_ef_sc_hd__decap_12
X_3058_ _0153_ _0154_ _0173_ VGND VGND VPWR VPWR _0174_ sky130_fd_sc_hd__a21oi_2
XFILLER_0_77_365 VGND VGND VPWR VPWR sky130_fd_sc_hd__fill_2
XFILLER_0_18_421 VGND VGND VPWR VPWR sky130_fd_sc_hd__fill_1
XFILLER_0_45_295 VPWR VGND VPWR VGND sky130_ef_sc_hd__decap_12
XFILLER_0_13_181 VGND VGND VPWR VPWR sky130_fd_sc_hd__decap_8
XFILLER_0_68_332 VGND VGND VPWR VPWR sky130_fd_sc_hd__decap_6
XFILLER_0_68_354 VGND VGND VPWR VPWR sky130_fd_sc_hd__decap_8
XFILLER_0_68_365 VPWR VGND VPWR VGND sky130_ef_sc_hd__decap_12
XPHY_60 VGND VGND VPWR VPWR sky130_fd_sc_hd__decap_3
XPHY_71 VGND VGND VPWR VPWR sky130_fd_sc_hd__decap_3
XPHY_82 VGND VGND VPWR VPWR sky130_fd_sc_hd__decap_3
XFILLER_0_68_398 VPWR VGND VPWR VGND sky130_ef_sc_hd__decap_12
XFILLER_0_22_26 VGND VGND VPWR VPWR sky130_fd_sc_hd__fill_2
XPHY_93 VGND VGND VPWR VPWR sky130_fd_sc_hd__decap_3
XFILLER_0_36_251 VGND VGND VPWR VPWR sky130_fd_sc_hd__fill_1
XFILLER_0_36_295 VPWR VGND VPWR VGND sky130_ef_sc_hd__decap_12
XFILLER_0_51_265 VGND VGND VPWR VPWR sky130_fd_sc_hd__decap_4
XFILLER_0_11_118 VPWR VGND VPWR VGND sky130_ef_sc_hd__decap_12
XFILLER_0_51_287 VGND VGND VPWR VPWR sky130_fd_sc_hd__fill_1
X_2360_ net42 _1536_ _1537_ net133 _1566_ VGND VGND VPWR VPWR _0017_ sky130_fd_sc_hd__a221o_1
X_2291_ net65 add_tmp\[3\] VGND VGND VPWR VPWR _1510_ sky130_fd_sc_hd__or2_1
XFILLER_0_47_23 VPWR VGND VPWR VGND sky130_ef_sc_hd__decap_12
X_4030_ _1156_ _1164_ VGND VGND VPWR VPWR _1166_ sky130_fd_sc_hd__nor2_1
XFILLER_0_59_332 VGND VGND VPWR VPWR sky130_fd_sc_hd__decap_4
XFILLER_0_63_55 VGND VGND VPWR VPWR sky130_fd_sc_hd__fill_1
XFILLER_0_59_343 VGND VGND VPWR VPWR sky130_fd_sc_hd__fill_1
XFILLER_0_59_354 VGND VGND VPWR VPWR sky130_fd_sc_hd__fill_1
X_3814_ _0928_ _0930_ _0931_ VGND VGND VPWR VPWR _0932_ sky130_fd_sc_hd__a21o_1
XFILLER_0_6_134 VGND VGND VPWR VPWR sky130_fd_sc_hd__decap_6
XFILLER_0_6_156 VGND VGND VPWR VPWR sky130_fd_sc_hd__decap_3
X_3745_ _0183_ VGND VGND VPWR VPWR _0857_ sky130_fd_sc_hd__clkbuf_2
XFILLER_0_27_284 VGND VGND VPWR VPWR sky130_fd_sc_hd__fill_2
X_3676_ _0782_ _0783_ _0779_ _0711_ VGND VGND VPWR VPWR _0785_ sky130_fd_sc_hd__o211ai_2
X_2627_ _1804_ _1805_ _1765_ _1772_ VGND VGND VPWR VPWR _1807_ sky130_fd_sc_hd__a211oi_2
XFILLER_0_63_3 VPWR VGND VPWR VGND sky130_ef_sc_hd__decap_12
X_2558_ _1738_ _1739_ _1710_ VGND VGND VPWR VPWR _1740_ sky130_fd_sc_hd__a21o_1
XFILLER_0_10_195 VGND VGND VPWR VPWR sky130_fd_sc_hd__fill_1
X_2489_ _1659_ _1670_ _1673_ _1664_ VGND VGND VPWR VPWR _1674_ sky130_fd_sc_hd__a22o_1
X_4228_ _1377_ _1371_ VGND VGND VPWR VPWR _1379_ sky130_fd_sc_hd__and2b_1
X_4159_ _1302_ _1304_ VGND VGND VPWR VPWR _1305_ sky130_fd_sc_hd__and2_1
XFILLER_0_77_195 VGND VGND VPWR VPWR sky130_fd_sc_hd__fill_1
XFILLER_0_65_335 VGND VGND VPWR VPWR sky130_fd_sc_hd__fill_1
XFILLER_0_21_449 VGND VGND VPWR VPWR sky130_fd_sc_hd__decap_8
Xinput12 in_a[3] VGND VGND VPWR VPWR net12 sky130_fd_sc_hd__buf_4
XFILLER_0_64_390 VPWR VGND VPWR VGND sky130_ef_sc_hd__decap_12
XFILLER_0_71_349 VGND VGND VPWR VPWR sky130_fd_sc_hd__decap_6
Xinput23 in_b[13] VGND VGND VPWR VPWR net23 sky130_fd_sc_hd__buf_2
Xinput34 in_b[9] VGND VGND VPWR VPWR net34 sky130_fd_sc_hd__buf_2
X_3530_ net30 net7 VGND VGND VPWR VPWR _0641_ sky130_fd_sc_hd__and2_1
XFILLER_0_3_159 VGND VGND VPWR VPWR sky130_fd_sc_hd__decap_8
X_3461_ _0375_ _0245_ VGND VGND VPWR VPWR _0573_ sky130_fd_sc_hd__nand2_1
X_2412_ _1440_ _1608_ VGND VGND VPWR VPWR _1609_ sky130_fd_sc_hd__xnor2_1
X_3392_ _0411_ _0413_ _0503_ _0504_ VGND VGND VPWR VPWR _0505_ sky130_fd_sc_hd__a211oi_1
X_2343_ _1492_ VGND VGND VPWR VPWR _1553_ sky130_fd_sc_hd__buf_2
X_4013_ _1144_ _1145_ _1139_ VGND VGND VPWR VPWR _1148_ sky130_fd_sc_hd__a21o_1
X_2274_ net143 _1495_ VGND VGND VPWR VPWR _1496_ sky130_fd_sc_hd__nand2_1
XFILLER_0_74_65 VPWR VGND VPWR VGND sky130_ef_sc_hd__decap_12
XFILLER_0_59_151 VPWR VGND VPWR VGND sky130_ef_sc_hd__decap_12
XFILLER_0_74_132 VGND VGND VPWR VPWR sky130_fd_sc_hd__decap_4
XFILLER_0_15_221 VGND VGND VPWR VPWR sky130_fd_sc_hd__decap_3
X_3728_ _0837_ _0376_ _0834_ _0835_ VGND VGND VPWR VPWR _0838_ sky130_fd_sc_hd__a22oi_2
X_3659_ _0561_ _0476_ VGND VGND VPWR VPWR _0768_ sky130_fd_sc_hd__nand2_1
XFILLER_0_30_235 VGND VGND VPWR VPWR sky130_fd_sc_hd__fill_1
XFILLER_0_38_302 VGND VGND VPWR VPWR sky130_fd_sc_hd__decap_6
XFILLER_0_61_393 VPWR VGND VPWR VGND sky130_ef_sc_hd__decap_12
XTAP_408 VGND VPWR sky130_fd_sc_hd__tapvpwrvgnd_1
XTAP_419 VGND VPWR sky130_fd_sc_hd__tapvpwrvgnd_1
XFILLER_0_28_69 VGND VGND VPWR VPWR sky130_fd_sc_hd__fill_1
XFILLER_0_76_408 VPWR VGND VPWR VGND sky130_ef_sc_hd__decap_12
XFILLER_0_44_57 VGND VGND VPWR VPWR sky130_fd_sc_hd__decap_8
X_2961_ _0077_ VGND VGND VPWR VPWR _0078_ sky130_fd_sc_hd__clkbuf_2
XFILLER_0_29_357 VGND VGND VPWR VPWR sky130_fd_sc_hd__fill_1
X_2892_ _2062_ _2066_ VGND VGND VPWR VPWR _2067_ sky130_fd_sc_hd__nor2_1
XFILLER_0_71_102 VGND VGND VPWR VPWR sky130_fd_sc_hd__decap_8
XFILLER_0_71_113 VPWR VGND VPWR VGND sky130_ef_sc_hd__decap_12
XFILLER_0_8_46 VPWR VGND VPWR VGND sky130_ef_sc_hd__decap_12
XFILLER_0_4_457 VGND VGND VPWR VPWR sky130_fd_sc_hd__decap_6
XFILLER_0_12_213 VPWR VGND VPWR VGND sky130_ef_sc_hd__decap_12
X_3513_ _0621_ _0622_ _0609_ VGND VGND VPWR VPWR _0624_ sky130_fd_sc_hd__o21ai_1
X_3444_ _0554_ _0543_ _0544_ VGND VGND VPWR VPWR _0556_ sky130_fd_sc_hd__nand3_1
X_3375_ _0365_ _0395_ _0486_ _0487_ VGND VGND VPWR VPWR _0488_ sky130_fd_sc_hd__o211ai_4
X_2326_ _1308_ _1538_ VGND VGND VPWR VPWR _1539_ sky130_fd_sc_hd__nand2_1
X_2257_ _0831_ net63 VGND VGND VPWR VPWR _1481_ sky130_fd_sc_hd__nor2_1
XFILLER_0_26_3 VPWR VGND VPWR VGND sky130_ef_sc_hd__decap_12
X_2188_ net45 add_tmp\[18\] VGND VGND VPWR VPWR _1412_ sky130_fd_sc_hd__or2_1
XFILLER_0_35_305 VPWR VGND VPWR VGND sky130_ef_sc_hd__decap_12
XFILLER_0_47_165 VGND VGND VPWR VPWR sky130_fd_sc_hd__decap_3
XFILLER_0_47_198 VPWR VGND VPWR VGND sky130_ef_sc_hd__decap_12
XFILLER_0_62_102 VPWR VGND VPWR VGND sky130_ef_sc_hd__decap_12
XFILLER_0_43_393 VPWR VGND VPWR VGND sky130_ef_sc_hd__decap_12
XFILLER_0_14_27 VGND VGND VPWR VPWR sky130_fd_sc_hd__fill_1
XFILLER_0_53_113 VGND VGND VPWR VPWR sky130_fd_sc_hd__decap_8
XFILLER_0_53_146 VGND VGND VPWR VPWR sky130_fd_sc_hd__fill_1
XFILLER_0_1_405 VPWR VGND VPWR VGND sky130_ef_sc_hd__decap_12
XFILLER_0_1_449 VPWR VGND VPWR VGND sky130_ef_sc_hd__decap_12
XTAP_205 VGND VPWR sky130_fd_sc_hd__tapvpwrvgnd_1
XFILLER_0_39_46 VGND VGND VPWR VPWR sky130_fd_sc_hd__decap_8
XFILLER_0_39_57 VPWR VGND VPWR VGND sky130_ef_sc_hd__decap_12
XTAP_238 VGND VPWR sky130_fd_sc_hd__tapvpwrvgnd_1
XTAP_227 VGND VPWR sky130_fd_sc_hd__tapvpwrvgnd_1
XTAP_216 VGND VPWR sky130_fd_sc_hd__tapvpwrvgnd_1
XTAP_249 VGND VPWR sky130_fd_sc_hd__tapvpwrvgnd_1
X_3160_ _0272_ _0273_ _0274_ VGND VGND VPWR VPWR _0275_ sky130_fd_sc_hd__nand3_1
X_3091_ _0109_ _0113_ _0110_ VGND VGND VPWR VPWR _0207_ sky130_fd_sc_hd__o21ba_1
XFILLER_0_12_9 VGND VGND VPWR VPWR sky130_fd_sc_hd__fill_1
XFILLER_0_76_205 VGND VGND VPWR VPWR sky130_fd_sc_hd__fill_1
X_3993_ _0952_ _1087_ VGND VGND VPWR VPWR _1126_ sky130_fd_sc_hd__nor2_1
XFILLER_0_29_132 VGND VGND VPWR VPWR sky130_fd_sc_hd__decap_4
X_2944_ net103 _2055_ _2117_ _2118_ VGND VGND VPWR VPWR _2119_ sky130_fd_sc_hd__o211a_1
XFILLER_0_72_411 VGND VGND VPWR VPWR sky130_fd_sc_hd__fill_1
X_2875_ _1983_ net145 _2050_ VGND VGND VPWR VPWR _2051_ sky130_fd_sc_hd__a21oi_1
XFILLER_0_72_444 VPWR VGND VPWR VGND sky130_ef_sc_hd__decap_12
XFILLER_0_4_221 VPWR VGND VPWR VGND sky130_ef_sc_hd__decap_12
XFILLER_0_44_168 VGND VGND VPWR VPWR sky130_fd_sc_hd__decap_8
XFILLER_0_20_92 VGND VGND VPWR VPWR sky130_fd_sc_hd__decap_6
XFILLER_0_40_341 VPWR VGND VPWR VGND sky130_ef_sc_hd__decap_12
X_3427_ _0535_ _0538_ VGND VGND VPWR VPWR _0539_ sky130_fd_sc_hd__xor2_2
X_3358_ _0470_ VGND VGND VPWR VPWR _0471_ sky130_fd_sc_hd__clkbuf_2
XTAP_750 VGND VPWR sky130_fd_sc_hd__tapvpwrvgnd_1
XTAP_761 VGND VPWR sky130_fd_sc_hd__tapvpwrvgnd_1
XTAP_794 VGND VPWR sky130_fd_sc_hd__tapvpwrvgnd_1
XTAP_783 VGND VPWR sky130_fd_sc_hd__tapvpwrvgnd_1
XTAP_772 VGND VPWR sky130_fd_sc_hd__tapvpwrvgnd_1
XFILLER_0_29_90 VGND VGND VPWR VPWR sky130_fd_sc_hd__decap_6
X_2309_ net68 add_tmp\[6\] VGND VGND VPWR VPWR _1525_ sky130_fd_sc_hd__or2_1
X_3289_ _0402_ VGND VGND VPWR VPWR _0403_ sky130_fd_sc_hd__buf_2
XFILLER_0_35_113 VGND VGND VPWR VPWR sky130_fd_sc_hd__decap_8
XFILLER_0_31_363 VGND VGND VPWR VPWR sky130_fd_sc_hd__fill_1
XFILLER_0_31_385 VGND VGND VPWR VPWR sky130_fd_sc_hd__decap_6
XFILLER_0_25_15 VPWR VGND VPWR VGND sky130_ef_sc_hd__decap_12
XFILLER_0_41_25 VPWR VGND VPWR VGND sky130_ef_sc_hd__decap_12
XFILLER_0_14_319 VGND VGND VPWR VPWR sky130_fd_sc_hd__fill_2
X_2660_ _1753_ VGND VGND VPWR VPWR _1839_ sky130_fd_sc_hd__clkbuf_2
X_2591_ _1771_ VGND VGND VPWR VPWR _0043_ sky130_fd_sc_hd__clkbuf_1
XFILLER_0_22_363 VGND VGND VPWR VPWR sky130_fd_sc_hd__fill_1
XFILLER_0_22_396 VPWR VGND VPWR VGND sky130_ef_sc_hd__decap_12
XFILLER_0_1_279 VGND VGND VPWR VPWR sky130_fd_sc_hd__fill_1
X_4261_ clknet_3_3__leaf_clk _0006_ net35 VGND VGND VPWR VPWR net66 sky130_fd_sc_hd__dfrtp_2
X_3212_ _0265_ VGND VGND VPWR VPWR _0326_ sky130_fd_sc_hd__clkbuf_2
X_4192_ _1282_ _1339_ VGND VGND VPWR VPWR _1341_ sky130_fd_sc_hd__xor2_1
X_3143_ _0239_ _0240_ _0257_ VGND VGND VPWR VPWR _0258_ sky130_fd_sc_hd__o21a_1
X_3074_ _0186_ _0187_ _0188_ VGND VGND VPWR VPWR _0190_ sky130_fd_sc_hd__a21o_1
XFILLER_0_49_249 VGND VGND VPWR VPWR sky130_fd_sc_hd__fill_1
XFILLER_0_64_208 VGND VGND VPWR VPWR sky130_fd_sc_hd__fill_1
X_3976_ _1031_ _1042_ VGND VGND VPWR VPWR _1108_ sky130_fd_sc_hd__or2b_1
XFILLER_0_57_271 VGND VGND VPWR VPWR sky130_fd_sc_hd__decap_8
X_2927_ _2098_ _2099_ _2100_ VGND VGND VPWR VPWR _2102_ sky130_fd_sc_hd__a21o_1
XFILLER_0_17_179 VPWR VGND VPWR VGND sky130_ef_sc_hd__decap_12
XFILLER_0_32_105 VGND VGND VPWR VPWR sky130_fd_sc_hd__decap_3
X_2858_ _1954_ _1965_ VGND VGND VPWR VPWR _2034_ sky130_fd_sc_hd__and2_1
XFILLER_0_72_296 VPWR VGND VPWR VGND sky130_ef_sc_hd__decap_12
XFILLER_0_13_352 VGND VGND VPWR VPWR sky130_fd_sc_hd__decap_8
XFILLER_0_32_149 VGND VGND VPWR VPWR sky130_fd_sc_hd__fill_2
X_2789_ _1954_ _1965_ VGND VGND VPWR VPWR _1966_ sky130_fd_sc_hd__xor2_1
XTAP_580 VGND VPWR sky130_fd_sc_hd__tapvpwrvgnd_1
XTAP_591 VGND VPWR sky130_fd_sc_hd__tapvpwrvgnd_1
XFILLER_0_36_411 VGND VGND VPWR VPWR sky130_fd_sc_hd__fill_1
XFILLER_0_55_219 VGND VGND VPWR VPWR sky130_fd_sc_hd__decap_4
XFILLER_0_52_35 VGND VGND VPWR VPWR sky130_fd_sc_hd__fill_1
X_3830_ _0874_ _0946_ _0947_ VGND VGND VPWR VPWR _0949_ sky130_fd_sc_hd__nand3_2
XFILLER_0_27_400 VGND VGND VPWR VPWR sky130_fd_sc_hd__fill_2
X_3761_ _0529_ _0645_ _0873_ VGND VGND VPWR VPWR _0874_ sky130_fd_sc_hd__mux2_1
X_2712_ _1886_ _1887_ _1888_ VGND VGND VPWR VPWR _1890_ sky130_fd_sc_hd__a21oi_1
X_3692_ _0777_ _0800_ VGND VGND VPWR VPWR _0801_ sky130_fd_sc_hd__xor2_2
X_2643_ _1667_ _1660_ _1799_ _1821_ VGND VGND VPWR VPWR _1822_ sky130_fd_sc_hd__and4_1
XFILLER_0_10_300 VGND VGND VPWR VPWR sky130_fd_sc_hd__decap_8
X_2574_ _1754_ VGND VGND VPWR VPWR _1755_ sky130_fd_sc_hd__buf_6
X_4313_ clknet_3_4__leaf_clk _0058_ net35 VGND VGND VPWR VPWR add_tmp\[20\] sky130_fd_sc_hd__dfrtp_1
X_4244_ _1380_ _1381_ _1395_ VGND VGND VPWR VPWR _1396_ sky130_fd_sc_hd__o21ai_1
X_4175_ _1228_ _1273_ VGND VGND VPWR VPWR _1323_ sky130_fd_sc_hd__nor2_1
X_3126_ _1679_ _0155_ _0158_ _1701_ VGND VGND VPWR VPWR _0241_ sky130_fd_sc_hd__a22o_1
XFILLER_0_77_333 VGND VGND VPWR VPWR sky130_fd_sc_hd__decap_3
X_3057_ _0163_ _0172_ VGND VGND VPWR VPWR _0173_ sky130_fd_sc_hd__xnor2_1
XFILLER_0_18_400 VGND VGND VPWR VPWR sky130_fd_sc_hd__decap_6
X_3959_ _1083_ _1088_ VGND VGND VPWR VPWR _1089_ sky130_fd_sc_hd__xnor2_1
XFILLER_0_33_447 VGND VGND VPWR VPWR sky130_fd_sc_hd__fill_1
XFILLER_0_5_371 VGND VGND VPWR VPWR sky130_fd_sc_hd__decap_4
XFILLER_0_5_393 VGND VGND VPWR VPWR sky130_fd_sc_hd__decap_4
XFILLER_0_60_288 VGND VGND VPWR VPWR sky130_fd_sc_hd__decap_4
XPHY_50 VGND VGND VPWR VPWR sky130_fd_sc_hd__decap_3
XPHY_61 VGND VGND VPWR VPWR sky130_fd_sc_hd__decap_3
XPHY_72 VGND VGND VPWR VPWR sky130_fd_sc_hd__decap_3
XPHY_83 VGND VGND VPWR VPWR sky130_fd_sc_hd__decap_3
XFILLER_0_68_377 VPWR VGND VPWR VGND sky130_ef_sc_hd__decap_12
XPHY_94 VGND VGND VPWR VPWR sky130_fd_sc_hd__decap_3
XFILLER_0_51_244 VGND VGND VPWR VPWR sky130_fd_sc_hd__decap_8
XFILLER_0_51_277 VGND VGND VPWR VPWR sky130_fd_sc_hd__decap_3
X_2290_ net58 _1502_ _1504_ add_tmp\[2\] _1509_ VGND VGND VPWR VPWR _0004_ sky130_fd_sc_hd__a221o_1
XFILLER_0_47_35 VGND VGND VPWR VPWR sky130_fd_sc_hd__decap_6
XFILLER_0_47_57 VGND VGND VPWR VPWR sky130_fd_sc_hd__decap_6
XFILLER_0_2_15 VPWR VGND VPWR VGND sky130_ef_sc_hd__decap_12
X_3813_ _0839_ _0848_ VGND VGND VPWR VPWR _0931_ sky130_fd_sc_hd__nand2_1
XFILLER_0_27_252 VGND VGND VPWR VPWR sky130_fd_sc_hd__fill_1
XFILLER_0_27_263 VGND VGND VPWR VPWR sky130_fd_sc_hd__decap_8
X_3744_ _0855_ VGND VGND VPWR VPWR _0856_ sky130_fd_sc_hd__dlymetal6s2s_1
XFILLER_0_6_168 VGND VGND VPWR VPWR sky130_fd_sc_hd__decap_3
X_3675_ _0779_ _0711_ _0782_ _0783_ VGND VGND VPWR VPWR _0784_ sky130_fd_sc_hd__a211o_1
X_2626_ net150 _1772_ _1804_ _1805_ VGND VGND VPWR VPWR _1806_ sky130_fd_sc_hd__o211a_4
XFILLER_0_42_277 VGND VGND VPWR VPWR sky130_fd_sc_hd__fill_2
XFILLER_0_42_288 VGND VGND VPWR VPWR sky130_fd_sc_hd__decap_6
XFILLER_0_10_141 VPWR VGND VPWR VGND sky130_ef_sc_hd__decap_12
X_2557_ _1713_ _1714_ _1737_ VGND VGND VPWR VPWR _1739_ sky130_fd_sc_hd__nand3_1
XFILLER_0_56_3 VGND VGND VPWR VPWR sky130_fd_sc_hd__decap_4
X_2488_ _1672_ VGND VGND VPWR VPWR _1673_ sky130_fd_sc_hd__clkbuf_2
X_4227_ _1371_ _1377_ VGND VGND VPWR VPWR _1378_ sky130_fd_sc_hd__and2b_1
X_4158_ _1303_ _1250_ _1301_ VGND VGND VPWR VPWR _1304_ sky130_fd_sc_hd__o21ai_1
XFILLER_0_37_90 VGND VGND VPWR VPWR sky130_fd_sc_hd__decap_8
XFILLER_0_69_108 VGND VGND VPWR VPWR sky130_fd_sc_hd__decap_4
X_4089_ _1228_ _1180_ _1182_ _1655_ VGND VGND VPWR VPWR _1230_ sky130_fd_sc_hd__a31o_1
X_3109_ _2068_ _0094_ _0224_ VGND VGND VPWR VPWR _0225_ sky130_fd_sc_hd__a21oi_1
XFILLER_0_77_141 VPWR VGND VPWR VGND sky130_ef_sc_hd__decap_12
XFILLER_0_33_233 VGND VGND VPWR VPWR sky130_fd_sc_hd__fill_1
XFILLER_0_73_391 VGND VGND VPWR VPWR sky130_fd_sc_hd__fill_1
XFILLER_0_21_428 VGND VGND VPWR VPWR sky130_fd_sc_hd__fill_1
XFILLER_0_33_15 VPWR VGND VPWR VGND sky130_ef_sc_hd__decap_12
XFILLER_0_68_141 VPWR VGND VPWR VGND sky130_ef_sc_hd__decap_12
Xinput13 in_a[4] VGND VGND VPWR VPWR net13 sky130_fd_sc_hd__buf_6
Xinput24 in_b[14] VGND VGND VPWR VPWR net24 sky130_fd_sc_hd__buf_2
Xinput35 rst_n VGND VGND VPWR VPWR net35 sky130_fd_sc_hd__buf_12
X_3460_ _0570_ _0571_ VGND VGND VPWR VPWR _0572_ sky130_fd_sc_hd__nor2_1
X_2411_ _1449_ _1607_ VGND VGND VPWR VPWR _1608_ sky130_fd_sc_hd__nand2_1
X_3391_ _0501_ _0502_ _0406_ VGND VGND VPWR VPWR _0504_ sky130_fd_sc_hd__o21a_1
X_2342_ _1551_ add_tmp\[12\] _1522_ VGND VGND VPWR VPWR _1552_ sky130_fd_sc_hd__mux2_1
XFILLER_0_42_9 VGND VGND VPWR VPWR sky130_fd_sc_hd__decap_4
X_4012_ _1139_ _1144_ _1145_ VGND VGND VPWR VPWR _1147_ sky130_fd_sc_hd__and3_1
X_2273_ _1492_ VGND VGND VPWR VPWR _1495_ sky130_fd_sc_hd__buf_2
XFILLER_0_74_77 VGND VGND VPWR VPWR sky130_fd_sc_hd__decap_6
XFILLER_0_59_163 VGND VGND VPWR VPWR sky130_fd_sc_hd__decap_4
X_3727_ _0629_ VGND VGND VPWR VPWR _0837_ sky130_fd_sc_hd__clkbuf_2
X_3658_ _0765_ _0766_ VGND VGND VPWR VPWR _0767_ sky130_fd_sc_hd__nor2_1
X_2609_ _1786_ _1788_ VGND VGND VPWR VPWR _1789_ sky130_fd_sc_hd__xnor2_1
X_3589_ _2075_ _0120_ net7 _1900_ VGND VGND VPWR VPWR _0699_ sky130_fd_sc_hd__a22o_1
XFILLER_0_11_461 VGND VGND VPWR VPWR sky130_fd_sc_hd__fill_2
XFILLER_0_38_325 VGND VGND VPWR VPWR sky130_fd_sc_hd__fill_1
XFILLER_0_65_133 VPWR VGND VPWR VGND sky130_ef_sc_hd__decap_12
XFILLER_0_21_203 VGND VGND VPWR VPWR sky130_fd_sc_hd__decap_8
XFILLER_0_21_225 VGND VGND VPWR VPWR sky130_fd_sc_hd__fill_2
XFILLER_0_0_119 VPWR VGND VPWR VGND sky130_ef_sc_hd__decap_12
XTAP_409 VGND VPWR sky130_fd_sc_hd__tapvpwrvgnd_1
XFILLER_0_28_37 VGND VGND VPWR VPWR sky130_fd_sc_hd__fill_1
XFILLER_0_44_14 VGND VGND VPWR VPWR sky130_fd_sc_hd__decap_3
X_2960_ net22 VGND VGND VPWR VPWR _0077_ sky130_fd_sc_hd__dlymetal6s2s_1
X_2891_ _1796_ _2064_ _2065_ _2060_ VGND VGND VPWR VPWR _2066_ sky130_fd_sc_hd__a22oi_1
XFILLER_0_71_125 VPWR VGND VPWR VGND sky130_ef_sc_hd__decap_12
XFILLER_0_71_158 VGND VGND VPWR VPWR sky130_fd_sc_hd__fill_1
XFILLER_0_52_361 VGND VGND VPWR VPWR sky130_fd_sc_hd__decap_3
XFILLER_0_71_169 VPWR VGND VPWR VGND sky130_ef_sc_hd__decap_12
XFILLER_0_12_225 VPWR VGND VPWR VGND sky130_ef_sc_hd__decap_12
XFILLER_0_8_58 VPWR VGND VPWR VGND sky130_ef_sc_hd__decap_12
X_3512_ _0609_ _0621_ _0622_ VGND VGND VPWR VPWR _0623_ sky130_fd_sc_hd__or3_1
XFILLER_0_69_33 VGND VGND VPWR VPWR sky130_fd_sc_hd__fill_1
XFILLER_0_69_55 VGND VGND VPWR VPWR sky130_fd_sc_hd__fill_1
X_3443_ _0543_ _0544_ _0554_ VGND VGND VPWR VPWR _0555_ sky130_fd_sc_hd__a21o_1
XFILLER_0_20_280 VPWR VGND VPWR VGND sky130_ef_sc_hd__decap_12
X_3374_ _0485_ _0457_ _0458_ VGND VGND VPWR VPWR _0487_ sky130_fd_sc_hd__nand3_2
X_2325_ net71 add_tmp\[9\] VGND VGND VPWR VPWR _1538_ sky130_fd_sc_hd__or2_1
X_2256_ _0821_ net63 VGND VGND VPWR VPWR _1480_ sky130_fd_sc_hd__and2_1
X_2187_ net45 add_tmp\[18\] VGND VGND VPWR VPWR _1411_ sky130_fd_sc_hd__nand2_1
XFILLER_0_19_3 VGND VGND VPWR VPWR sky130_fd_sc_hd__fill_1
XFILLER_0_47_111 VGND VGND VPWR VPWR sky130_fd_sc_hd__fill_1
XFILLER_0_35_317 VGND VGND VPWR VPWR sky130_fd_sc_hd__decap_8
XFILLER_0_62_114 VGND VGND VPWR VPWR sky130_fd_sc_hd__decap_4
XFILLER_0_62_147 VGND VGND VPWR VPWR sky130_fd_sc_hd__fill_1
XFILLER_0_62_158 VPWR VGND VPWR VGND sky130_ef_sc_hd__decap_12
XFILLER_0_30_49 VGND VGND VPWR VPWR sky130_fd_sc_hd__decap_3
XFILLER_0_53_169 VGND VGND VPWR VPWR sky130_fd_sc_hd__decap_4
XFILLER_0_1_417 VPWR VGND VPWR VGND sky130_ef_sc_hd__decap_12
XFILLER_0_61_191 VGND VGND VPWR VPWR sky130_fd_sc_hd__fill_2
XTAP_206 VGND VPWR sky130_fd_sc_hd__tapvpwrvgnd_1
XTAP_239 VGND VPWR sky130_fd_sc_hd__tapvpwrvgnd_1
XTAP_228 VGND VPWR sky130_fd_sc_hd__tapvpwrvgnd_1
XTAP_217 VGND VPWR sky130_fd_sc_hd__tapvpwrvgnd_1
XFILLER_0_39_69 VPWR VGND VPWR VGND sky130_ef_sc_hd__decap_12
X_3090_ _0204_ _0205_ _0102_ _0101_ _1800_ VGND VGND VPWR VPWR _0206_ sky130_fd_sc_hd__a32o_1
XFILLER_0_55_57 VGND VGND VPWR VPWR sky130_fd_sc_hd__fill_1
X_3992_ _0645_ _0873_ _1087_ VGND VGND VPWR VPWR _1125_ sky130_fd_sc_hd__and3b_1
XFILLER_0_29_111 VGND VGND VPWR VPWR sky130_fd_sc_hd__fill_1
XFILLER_0_71_45 VGND VGND VPWR VPWR sky130_fd_sc_hd__decap_4
X_2943_ _2041_ _2115_ _2116_ VGND VGND VPWR VPWR _2118_ sky130_fd_sc_hd__nand3b_2
XFILLER_0_29_166 VGND VGND VPWR VPWR sky130_fd_sc_hd__fill_2
X_2874_ _1981_ _1980_ VGND VGND VPWR VPWR _2050_ sky130_fd_sc_hd__and2b_1
XFILLER_0_72_456 VGND VGND VPWR VPWR sky130_fd_sc_hd__decap_6
XFILLER_0_4_233 VPWR VGND VPWR VGND sky130_ef_sc_hd__decap_12
XFILLER_0_25_361 VPWR VGND VPWR VGND sky130_ef_sc_hd__decap_12
XFILLER_0_32_309 VGND VGND VPWR VPWR sky130_fd_sc_hd__decap_8
X_3426_ _0536_ _0434_ _0537_ VGND VGND VPWR VPWR _0538_ sky130_fd_sc_hd__a21bo_1
X_3357_ net23 VGND VGND VPWR VPWR _0470_ sky130_fd_sc_hd__clkbuf_2
XTAP_740 VGND VPWR sky130_fd_sc_hd__tapvpwrvgnd_1
XTAP_751 VGND VPWR sky130_fd_sc_hd__tapvpwrvgnd_1
XTAP_795 VGND VPWR sky130_fd_sc_hd__tapvpwrvgnd_1
XTAP_784 VGND VPWR sky130_fd_sc_hd__tapvpwrvgnd_1
XTAP_773 VGND VPWR sky130_fd_sc_hd__tapvpwrvgnd_1
XTAP_762 VGND VPWR sky130_fd_sc_hd__tapvpwrvgnd_1
X_2308_ _1524_ VGND VGND VPWR VPWR _0007_ sky130_fd_sc_hd__clkbuf_1
X_3288_ _0329_ VGND VGND VPWR VPWR _0402_ sky130_fd_sc_hd__inv_2
X_2239_ net59 add_tmp\[30\] VGND VGND VPWR VPWR _1463_ sky130_fd_sc_hd__or2_1
XFILLER_0_35_103 VGND VGND VPWR VPWR sky130_fd_sc_hd__fill_1
XFILLER_0_16_361 VGND VGND VPWR VPWR sky130_fd_sc_hd__decap_3
XFILLER_0_35_169 VPWR VGND VPWR VGND sky130_ef_sc_hd__decap_12
XFILLER_0_8_3 VPWR VGND VPWR VGND sky130_ef_sc_hd__decap_12
XFILLER_0_25_27 VPWR VGND VPWR VGND sky130_ef_sc_hd__decap_12
XFILLER_0_39_453 VGND VGND VPWR VPWR sky130_fd_sc_hd__fill_1
XFILLER_0_41_15 VGND VGND VPWR VPWR sky130_fd_sc_hd__fill_2
XFILLER_0_41_37 VGND VGND VPWR VPWR sky130_fd_sc_hd__decap_4
XFILLER_0_66_250 VGND VGND VPWR VPWR sky130_fd_sc_hd__fill_2
XFILLER_0_66_272 VGND VGND VPWR VPWR sky130_fd_sc_hd__fill_1
XFILLER_0_26_125 VPWR VGND VPWR VGND sky130_ef_sc_hd__decap_12
XFILLER_0_14_309 VGND VGND VPWR VPWR sky130_fd_sc_hd__decap_3
XFILLER_0_1_214 VGND VGND VPWR VPWR sky130_fd_sc_hd__decap_4
XFILLER_0_1_203 VGND VGND VPWR VPWR sky130_fd_sc_hd__decap_8
X_2590_ add_tmp\[5\] _1770_ _1490_ VGND VGND VPWR VPWR _1771_ sky130_fd_sc_hd__mux2_1
X_4260_ clknet_3_3__leaf_clk _0005_ net35 VGND VGND VPWR VPWR net65 sky130_fd_sc_hd__dfrtp_2
X_4191_ _1332_ _1338_ VGND VGND VPWR VPWR _1339_ sky130_fd_sc_hd__xnor2_1
XFILLER_0_66_23 VGND VGND VPWR VPWR sky130_fd_sc_hd__fill_1
X_3211_ net91 _0287_ net124 VGND VGND VPWR VPWR _0325_ sky130_fd_sc_hd__nand3_2
X_3142_ _0247_ _0256_ VGND VGND VPWR VPWR _0257_ sky130_fd_sc_hd__xnor2_2
X_3073_ _0186_ _0187_ _0188_ VGND VGND VPWR VPWR _0189_ sky130_fd_sc_hd__nand3_1
XFILLER_0_10_7 VPWR VGND VPWR VGND sky130_ef_sc_hd__decap_12
X_3975_ _1105_ _1106_ VGND VGND VPWR VPWR _1107_ sky130_fd_sc_hd__or2_1
X_2926_ _2098_ _2099_ _2100_ VGND VGND VPWR VPWR _2101_ sky130_fd_sc_hd__nand3_1
XFILLER_0_57_294 VGND VGND VPWR VPWR sky130_fd_sc_hd__fill_1
XFILLER_0_72_231 VGND VGND VPWR VPWR sky130_fd_sc_hd__decap_4
X_2857_ _1957_ _1964_ VGND VGND VPWR VPWR _2033_ sky130_fd_sc_hd__and2_1
XFILLER_0_72_253 VPWR VGND VPWR VGND sky130_ef_sc_hd__decap_12
XFILLER_0_31_92 VGND VGND VPWR VPWR sky130_fd_sc_hd__decap_3
XFILLER_0_32_139 VGND VGND VPWR VPWR sky130_fd_sc_hd__fill_1
X_2788_ _1957_ _1964_ VGND VGND VPWR VPWR _1965_ sky130_fd_sc_hd__xor2_1
X_3409_ _1681_ _0402_ VGND VGND VPWR VPWR _0521_ sky130_fd_sc_hd__nor2_1
XTAP_570 VGND VPWR sky130_fd_sc_hd__tapvpwrvgnd_1
XTAP_581 VGND VPWR sky130_fd_sc_hd__tapvpwrvgnd_1
XTAP_592 VGND VPWR sky130_fd_sc_hd__tapvpwrvgnd_1
XFILLER_0_52_25 VGND VGND VPWR VPWR sky130_fd_sc_hd__decap_3
XFILLER_0_6_306 VGND VGND VPWR VPWR sky130_fd_sc_hd__fill_2
XFILLER_0_27_445 VGND VGND VPWR VPWR sky130_fd_sc_hd__decap_3
X_3760_ _0790_ _0791_ VGND VGND VPWR VPWR _0873_ sky130_fd_sc_hd__nand2_1
X_2711_ _1886_ _1887_ _1888_ VGND VGND VPWR VPWR _1889_ sky130_fd_sc_hd__and3_4
X_3691_ _0799_ _0798_ VGND VGND VPWR VPWR _0800_ sky130_fd_sc_hd__nand2_2
XFILLER_0_54_297 VGND VGND VPWR VPWR sky130_fd_sc_hd__fill_1
X_2642_ _1820_ VGND VGND VPWR VPWR _1821_ sky130_fd_sc_hd__buf_2
X_2573_ net29 VGND VGND VPWR VPWR _1754_ sky130_fd_sc_hd__buf_8
XFILLER_0_77_55 VGND VGND VPWR VPWR sky130_fd_sc_hd__fill_1
X_4312_ clknet_3_4__leaf_clk _0057_ net35 VGND VGND VPWR VPWR add_tmp\[19\] sky130_fd_sc_hd__dfrtp_2
X_4243_ _1382_ _1384_ VGND VGND VPWR VPWR _1395_ sky130_fd_sc_hd__or2b_1
X_4174_ _1320_ _1321_ VGND VGND VPWR VPWR _1322_ sky130_fd_sc_hd__nand2_1
X_3125_ _0206_ _0214_ VGND VGND VPWR VPWR _0240_ sky130_fd_sc_hd__and2_1
X_3056_ _0170_ _0171_ VGND VGND VPWR VPWR _0172_ sky130_fd_sc_hd__xor2_2
XFILLER_0_26_81 VGND VGND VPWR VPWR sky130_fd_sc_hd__decap_3
XFILLER_0_77_345 VGND VGND VPWR VPWR sky130_fd_sc_hd__fill_1
XFILLER_0_45_220 VGND VGND VPWR VPWR sky130_fd_sc_hd__decap_4
XFILLER_0_9_199 VGND VGND VPWR VPWR sky130_fd_sc_hd__fill_1
X_3958_ _0876_ _1087_ VGND VGND VPWR VPWR _1088_ sky130_fd_sc_hd__xor2_1
X_3889_ _1009_ _1010_ _1011_ VGND VGND VPWR VPWR _1013_ sky130_fd_sc_hd__a21oi_1
X_2909_ _2073_ _2083_ VGND VGND VPWR VPWR _2084_ sky130_fd_sc_hd__xor2_1
XFILLER_0_60_201 VGND VGND VPWR VPWR sky130_fd_sc_hd__fill_1
XPHY_40 VGND VGND VPWR VPWR sky130_fd_sc_hd__decap_3
XPHY_51 VGND VGND VPWR VPWR sky130_fd_sc_hd__decap_3
XPHY_62 VGND VGND VPWR VPWR sky130_fd_sc_hd__decap_3
XPHY_73 VGND VGND VPWR VPWR sky130_fd_sc_hd__decap_3
XFILLER_0_68_389 VGND VGND VPWR VPWR sky130_fd_sc_hd__decap_6
XPHY_84 VGND VGND VPWR VPWR sky130_fd_sc_hd__decap_3
XPHY_95 VGND VGND VPWR VPWR sky130_fd_sc_hd__decap_3
XFILLER_0_36_242 VGND VGND VPWR VPWR sky130_fd_sc_hd__fill_1
XFILLER_0_36_253 VGND VGND VPWR VPWR sky130_fd_sc_hd__decap_8
XFILLER_0_47_47 VGND VGND VPWR VPWR sky130_fd_sc_hd__decap_8
XFILLER_0_2_27 VGND VGND VPWR VPWR sky130_fd_sc_hd__fill_1
XFILLER_0_63_57 VGND VGND VPWR VPWR sky130_fd_sc_hd__decap_8
XFILLER_0_19_209 VPWR VGND VPWR VGND sky130_ef_sc_hd__decap_12
XFILLER_0_74_348 VGND VGND VPWR VPWR sky130_fd_sc_hd__decap_4
X_3812_ _0926_ _0927_ _0911_ VGND VGND VPWR VPWR _0930_ sky130_fd_sc_hd__a21o_1
XFILLER_0_27_220 VGND VGND VPWR VPWR sky130_fd_sc_hd__fill_1
XFILLER_0_12_72 VPWR VGND VPWR VGND sky130_ef_sc_hd__decap_12
XFILLER_0_12_61 VGND VGND VPWR VPWR sky130_fd_sc_hd__fill_1
X_3743_ _2008_ _0709_ _0779_ VGND VGND VPWR VPWR _0855_ sky130_fd_sc_hd__a21bo_1
X_3674_ _0449_ _0534_ _0780_ _0781_ VGND VGND VPWR VPWR _0783_ sky130_fd_sc_hd__a22oi_2
X_2625_ _1803_ _1794_ _1795_ VGND VGND VPWR VPWR _1805_ sky130_fd_sc_hd__or3_4
XFILLER_0_10_120 VPWR VGND VPWR VGND sky130_ef_sc_hd__decap_12
XFILLER_0_2_386 VPWR VGND VPWR VGND sky130_ef_sc_hd__decap_12
X_2556_ _1713_ _1714_ _1737_ VGND VGND VPWR VPWR _1738_ sky130_fd_sc_hd__a21o_2
X_2487_ _1671_ VGND VGND VPWR VPWR _1672_ sky130_fd_sc_hd__clkbuf_2
XFILLER_0_10_197 VGND VGND VPWR VPWR sky130_fd_sc_hd__fill_1
X_4226_ _1373_ _1376_ VGND VGND VPWR VPWR _1377_ sky130_fd_sc_hd__xnor2_1
XFILLER_0_49_3 VGND VGND VPWR VPWR sky130_fd_sc_hd__decap_8
X_4157_ _1183_ VGND VGND VPWR VPWR _1303_ sky130_fd_sc_hd__buf_1
X_3108_ _0076_ _0093_ VGND VGND VPWR VPWR _0224_ sky130_fd_sc_hd__and2b_1
X_4088_ _1180_ _1182_ _1228_ VGND VGND VPWR VPWR _1229_ sky130_fd_sc_hd__a21oi_1
X_3039_ net22 VGND VGND VPWR VPWR _0155_ sky130_fd_sc_hd__clkbuf_2
XFILLER_0_77_153 VGND VGND VPWR VPWR sky130_fd_sc_hd__decap_4
XFILLER_0_53_90 VGND VGND VPWR VPWR sky130_fd_sc_hd__fill_1
XFILLER_0_77_197 VPWR VGND VPWR VGND sky130_ef_sc_hd__decap_12
XFILLER_0_65_337 VGND VGND VPWR VPWR sky130_fd_sc_hd__decap_8
XFILLER_0_33_27 VGND VGND VPWR VPWR sky130_fd_sc_hd__decap_3
XFILLER_0_68_153 VGND VGND VPWR VPWR sky130_fd_sc_hd__decap_3
XFILLER_0_56_337 VGND VGND VPWR VPWR sky130_fd_sc_hd__decap_4
Xinput14 in_a[5] VGND VGND VPWR VPWR net14 sky130_fd_sc_hd__buf_2
Xinput25 in_b[15] VGND VGND VPWR VPWR net25 sky130_fd_sc_hd__buf_1
XFILLER_0_12_418 VGND VGND VPWR VPWR sky130_fd_sc_hd__fill_2
X_2410_ _1433_ _1437_ _1451_ VGND VGND VPWR VPWR _1607_ sky130_fd_sc_hd__a21o_1
X_3390_ _0406_ _0501_ _0502_ VGND VGND VPWR VPWR _0503_ sky130_fd_sc_hd__nor3_2
X_2341_ _0984_ _1550_ VGND VGND VPWR VPWR _1551_ sky130_fd_sc_hd__xnor2_1
XFILLER_0_58_57 VPWR VGND VPWR VGND sky130_ef_sc_hd__decap_12
X_2272_ net36 _1493_ VGND VGND VPWR VPWR _1494_ sky130_fd_sc_hd__nand2_1
X_4011_ _1143_ _1140_ _1142_ VGND VGND VPWR VPWR _1145_ sky130_fd_sc_hd__or3_1
XFILLER_0_74_101 VPWR VGND VPWR VGND sky130_ef_sc_hd__decap_12
XFILLER_0_47_348 VGND VGND VPWR VPWR sky130_fd_sc_hd__decap_3
XFILLER_0_62_307 VGND VGND VPWR VPWR sky130_fd_sc_hd__fill_1
XFILLER_0_74_145 VGND VGND VPWR VPWR sky130_fd_sc_hd__fill_1
X_3726_ _0629_ _2063_ _0834_ _0835_ VGND VGND VPWR VPWR _0836_ sky130_fd_sc_hd__and4_1
X_3657_ _0357_ _0290_ _0569_ _0473_ VGND VGND VPWR VPWR _0766_ sky130_fd_sc_hd__and4_1
XFILLER_0_2_172 VGND VGND VPWR VPWR sky130_fd_sc_hd__fill_1
X_2608_ _1701_ _1787_ VGND VGND VPWR VPWR _1788_ sky130_fd_sc_hd__nand2_1
X_3588_ _0641_ _0639_ _0640_ VGND VGND VPWR VPWR _0698_ sky130_fd_sc_hd__a21bo_1
XFILLER_0_2_194 VGND VGND VPWR VPWR sky130_fd_sc_hd__fill_2
X_2539_ net12 VGND VGND VPWR VPWR _1721_ sky130_fd_sc_hd__buf_4
X_4209_ _1315_ _1331_ _1358_ VGND VGND VPWR VPWR _1359_ sky130_fd_sc_hd__o21ai_2
XFILLER_0_38_348 VGND VGND VPWR VPWR sky130_fd_sc_hd__fill_1
XFILLER_0_65_145 VGND VGND VPWR VPWR sky130_fd_sc_hd__decap_4
XFILLER_0_29_337 VPWR VGND VPWR VGND sky130_ef_sc_hd__decap_12
X_2890_ net148 VGND VGND VPWR VPWR _2065_ sky130_fd_sc_hd__inv_2
XFILLER_0_44_307 VGND VGND VPWR VPWR sky130_fd_sc_hd__fill_1
XFILLER_0_56_167 VGND VGND VPWR VPWR sky130_fd_sc_hd__decap_6
XFILLER_0_71_137 VGND VGND VPWR VPWR sky130_fd_sc_hd__decap_8
XFILLER_0_8_15 VPWR VGND VPWR VGND sky130_ef_sc_hd__decap_12
XFILLER_0_12_237 VPWR VGND VPWR VGND sky130_ef_sc_hd__decap_12
X_3511_ _0620_ _0614_ _0615_ VGND VGND VPWR VPWR _0622_ sky130_fd_sc_hd__and3_1
X_3442_ _0545_ _0553_ VGND VGND VPWR VPWR _0554_ sky130_fd_sc_hd__xnor2_2
X_3373_ _0457_ _0458_ _0485_ VGND VGND VPWR VPWR _0486_ sky130_fd_sc_hd__a21o_1
XFILLER_0_20_292 VPWR VGND VPWR VGND sky130_ef_sc_hd__decap_12
X_2324_ _1503_ VGND VGND VPWR VPWR _1537_ sky130_fd_sc_hd__clkbuf_2
X_2255_ net61 net62 _0821_ VGND VGND VPWR VPWR _1479_ sky130_fd_sc_hd__o21ai_1
X_2186_ _1408_ _1409_ VGND VGND VPWR VPWR _1410_ sky130_fd_sc_hd__nand2_1
XFILLER_0_75_421 VPWR VGND VPWR VGND sky130_ef_sc_hd__decap_12
XFILLER_0_34_70 VGND VGND VPWR VPWR sky130_fd_sc_hd__decap_6
X_3709_ _0816_ _0817_ VGND VGND VPWR VPWR _0818_ sky130_fd_sc_hd__nand2_1
XFILLER_0_70_181 VGND VGND VPWR VPWR sky130_fd_sc_hd__decap_8
XFILLER_0_11_292 VPWR VGND VPWR VGND sky130_ef_sc_hd__decap_12
XFILLER_0_66_421 VPWR VGND VPWR VGND sky130_ef_sc_hd__decap_12
XFILLER_0_26_307 VGND VGND VPWR VPWR sky130_fd_sc_hd__fill_1
XFILLER_0_38_178 VGND VGND VPWR VPWR sky130_fd_sc_hd__fill_1
XFILLER_0_19_381 VGND VGND VPWR VPWR sky130_fd_sc_hd__decap_8
XFILLER_0_30_17 VGND VGND VPWR VPWR sky130_fd_sc_hd__decap_8
XFILLER_0_34_340 VGND VGND VPWR VPWR sky130_fd_sc_hd__fill_1
XFILLER_0_1_429 VPWR VGND VPWR VGND sky130_ef_sc_hd__decap_12
XTAP_229 VGND VPWR sky130_fd_sc_hd__tapvpwrvgnd_1
XTAP_218 VGND VPWR sky130_fd_sc_hd__tapvpwrvgnd_1
XTAP_207 VGND VPWR sky130_fd_sc_hd__tapvpwrvgnd_1
X_3991_ _1034_ _1102_ VGND VGND VPWR VPWR _1123_ sky130_fd_sc_hd__nand2_1
XFILLER_0_69_270 VGND VGND VPWR VPWR sky130_fd_sc_hd__decap_8
X_2942_ _2115_ _2116_ _2041_ VGND VGND VPWR VPWR _2117_ sky130_fd_sc_hd__a21bo_1
XFILLER_0_71_57 VGND VGND VPWR VPWR sky130_fd_sc_hd__decap_6
XFILLER_0_44_104 VGND VGND VPWR VPWR sky130_fd_sc_hd__decap_4
X_2873_ _1994_ _2048_ VGND VGND VPWR VPWR _2049_ sky130_fd_sc_hd__xnor2_4
XFILLER_0_4_245 VGND VGND VPWR VPWR sky130_fd_sc_hd__decap_6
XFILLER_0_25_373 VGND VGND VPWR VPWR sky130_fd_sc_hd__decap_8
X_3425_ _1841_ _0181_ _0265_ _1839_ VGND VGND VPWR VPWR _0537_ sky130_fd_sc_hd__a22o_1
X_3356_ _0465_ _0466_ _0467_ VGND VGND VPWR VPWR _0469_ sky130_fd_sc_hd__a21o_1
XTAP_730 VGND VPWR sky130_fd_sc_hd__tapvpwrvgnd_1
XTAP_741 VGND VPWR sky130_fd_sc_hd__tapvpwrvgnd_1
XTAP_752 VGND VPWR sky130_fd_sc_hd__tapvpwrvgnd_1
XTAP_785 VGND VPWR sky130_fd_sc_hd__tapvpwrvgnd_1
XTAP_774 VGND VPWR sky130_fd_sc_hd__tapvpwrvgnd_1
XTAP_763 VGND VPWR sky130_fd_sc_hd__tapvpwrvgnd_1
X_2307_ net67 _1523_ _1495_ VGND VGND VPWR VPWR _1524_ sky130_fd_sc_hd__mux2_1
X_3287_ _0399_ _0400_ VGND VGND VPWR VPWR _0401_ sky130_fd_sc_hd__or2b_1
X_2238_ net59 add_tmp\[30\] VGND VGND VPWR VPWR _1462_ sky130_fd_sc_hd__nand2_1
XFILLER_0_31_3 VGND VGND VPWR VPWR sky130_fd_sc_hd__decap_6
X_2169_ _1049_ _1254_ _1265_ VGND VGND VPWR VPWR _1276_ sky130_fd_sc_hd__o21ba_1
XFILLER_0_48_421 VPWR VGND VPWR VGND sky130_ef_sc_hd__decap_12
XFILLER_0_0_93 VGND VGND VPWR VPWR sky130_fd_sc_hd__fill_1
XFILLER_0_63_413 VGND VGND VPWR VPWR sky130_fd_sc_hd__decap_4
XFILLER_0_75_295 VGND VGND VPWR VPWR sky130_fd_sc_hd__decap_3
XFILLER_0_31_321 VGND VGND VPWR VPWR sky130_fd_sc_hd__decap_8
XFILLER_0_25_39 VPWR VGND VPWR VGND sky130_ef_sc_hd__decap_12
XFILLER_0_66_262 VGND VGND VPWR VPWR sky130_fd_sc_hd__fill_1
XFILLER_0_26_115 VGND VGND VPWR VPWR sky130_fd_sc_hd__fill_1
XFILLER_0_26_137 VGND VGND VPWR VPWR sky130_fd_sc_hd__decap_3
XFILLER_0_22_354 VGND VGND VPWR VPWR sky130_fd_sc_hd__decap_4
XFILLER_0_22_365 VPWR VGND VPWR VGND sky130_ef_sc_hd__decap_12
X_4190_ _1336_ _1337_ VGND VGND VPWR VPWR _1338_ sky130_fd_sc_hd__nand2_1
X_3210_ _0236_ VGND VGND VPWR VPWR _0324_ sky130_fd_sc_hd__inv_2
XFILLER_0_66_68 VPWR VGND VPWR VGND sky130_ef_sc_hd__decap_12
X_3141_ _0254_ _0255_ VGND VGND VPWR VPWR _0256_ sky130_fd_sc_hd__xor2_2
X_3072_ _0116_ _0121_ _0119_ VGND VGND VPWR VPWR _0188_ sky130_fd_sc_hd__a21bo_1
XFILLER_0_49_218 VGND VGND VPWR VPWR sky130_fd_sc_hd__fill_1
XFILLER_0_9_337 VGND VGND VPWR VPWR sky130_fd_sc_hd__decap_8
X_3974_ _1094_ _1095_ _1104_ VGND VGND VPWR VPWR _1106_ sky130_fd_sc_hd__nor3_1
XFILLER_0_57_262 VGND VGND VPWR VPWR sky130_fd_sc_hd__decap_3
X_2925_ _2015_ _2018_ _2017_ VGND VGND VPWR VPWR _2100_ sky130_fd_sc_hd__a21bo_1
XFILLER_0_45_457 VGND VGND VPWR VPWR sky130_fd_sc_hd__fill_2
X_2856_ _2029_ _2030_ _1952_ net90 VGND VGND VPWR VPWR _2032_ sky130_fd_sc_hd__o211ai_2
XFILLER_0_72_265 VPWR VGND VPWR VGND sky130_ef_sc_hd__decap_12
X_2787_ _1961_ _1963_ VGND VGND VPWR VPWR _1964_ sky130_fd_sc_hd__xnor2_1
XFILLER_0_40_184 VGND VGND VPWR VPWR sky130_fd_sc_hd__fill_2
XFILLER_0_0_281 VPWR VGND VPWR VGND sky130_ef_sc_hd__decap_12
X_3408_ _0519_ VGND VGND VPWR VPWR _0520_ sky130_fd_sc_hd__clkbuf_2
XTAP_560 VGND VPWR sky130_fd_sc_hd__tapvpwrvgnd_1
XTAP_571 VGND VPWR sky130_fd_sc_hd__tapvpwrvgnd_1
XTAP_582 VGND VPWR sky130_fd_sc_hd__tapvpwrvgnd_1
XTAP_593 VGND VPWR sky130_fd_sc_hd__tapvpwrvgnd_1
X_3339_ _0448_ _0450_ _0444_ VGND VGND VPWR VPWR _0452_ sky130_fd_sc_hd__a21o_1
XFILLER_0_36_435 VGND VGND VPWR VPWR sky130_fd_sc_hd__decap_4
XFILLER_0_8_370 VGND VGND VPWR VPWR sky130_fd_sc_hd__fill_2
XFILLER_0_51_449 VPWR VGND VPWR VGND sky130_ef_sc_hd__decap_12
XFILLER_0_31_173 VGND VGND VPWR VPWR sky130_fd_sc_hd__fill_1
X_2710_ _1835_ _1846_ _1836_ VGND VGND VPWR VPWR _1888_ sky130_fd_sc_hd__a21bo_1
X_3690_ _0796_ _0797_ _0778_ _0718_ VGND VGND VPWR VPWR _0799_ sky130_fd_sc_hd__o211ai_1
XFILLER_0_42_405 VGND VGND VPWR VPWR sky130_fd_sc_hd__decap_8
X_2641_ net32 VGND VGND VPWR VPWR _1820_ sky130_fd_sc_hd__clkbuf_2
X_2572_ net28 VGND VGND VPWR VPWR _1753_ sky130_fd_sc_hd__buf_4
X_4311_ clknet_3_4__leaf_clk _0056_ net35 VGND VGND VPWR VPWR add_tmp\[18\] sky130_fd_sc_hd__dfrtp_1
XFILLER_0_22_195 VGND VGND VPWR VPWR sky130_fd_sc_hd__fill_1
X_4242_ _1337_ _1374_ _1336_ VGND VGND VPWR VPWR _1394_ sky130_fd_sc_hd__a21bo_1
X_4173_ _1278_ _1279_ _1318_ VGND VGND VPWR VPWR _1321_ sky130_fd_sc_hd__nand3_1
X_3124_ _0207_ _0213_ VGND VGND VPWR VPWR _0239_ sky130_fd_sc_hd__and2b_1
X_3055_ _0086_ _0089_ VGND VGND VPWR VPWR _0171_ sky130_fd_sc_hd__or2_4
XFILLER_0_9_167 VGND VGND VPWR VPWR sky130_fd_sc_hd__fill_1
X_3957_ _1085_ _1086_ VGND VGND VPWR VPWR _1087_ sky130_fd_sc_hd__or2_1
XFILLER_0_45_243 VGND VGND VPWR VPWR sky130_fd_sc_hd__fill_1
X_2908_ _2081_ _2082_ VGND VGND VPWR VPWR _2083_ sky130_fd_sc_hd__nor2_2
X_3888_ _1009_ _1010_ _1011_ VGND VGND VPWR VPWR _1012_ sky130_fd_sc_hd__and3_1
XFILLER_0_45_276 VGND VGND VPWR VPWR sky130_fd_sc_hd__decap_4
XFILLER_0_33_449 VPWR VGND VPWR VGND sky130_ef_sc_hd__decap_12
X_2839_ _1685_ _1867_ VGND VGND VPWR VPWR _2015_ sky130_fd_sc_hd__and2_1
XFILLER_0_6_70 VGND VGND VPWR VPWR sky130_fd_sc_hd__fill_1
XTAP_390 VGND VPWR sky130_fd_sc_hd__tapvpwrvgnd_1
XPHY_30 VGND VGND VPWR VPWR sky130_fd_sc_hd__decap_3
XPHY_41 VGND VGND VPWR VPWR sky130_fd_sc_hd__decap_3
XPHY_52 VGND VGND VPWR VPWR sky130_fd_sc_hd__decap_3
XPHY_63 VGND VGND VPWR VPWR sky130_fd_sc_hd__decap_3
XPHY_74 VGND VGND VPWR VPWR sky130_fd_sc_hd__decap_3
XFILLER_0_22_29 VGND VGND VPWR VPWR sky130_fd_sc_hd__decap_3
XPHY_85 VGND VGND VPWR VPWR sky130_fd_sc_hd__decap_3
XPHY_96 VGND VGND VPWR VPWR sky130_fd_sc_hd__decap_3
XFILLER_0_24_416 VGND VGND VPWR VPWR sky130_fd_sc_hd__decap_4
XFILLER_0_36_265 VGND VGND VPWR VPWR sky130_fd_sc_hd__decap_8
XFILLER_0_36_276 VGND VGND VPWR VPWR sky130_fd_sc_hd__fill_1
X_3811_ _0911_ _0926_ _0927_ VGND VGND VPWR VPWR _0928_ sky130_fd_sc_hd__nand3_1
XFILLER_0_6_104 VGND VGND VPWR VPWR sky130_fd_sc_hd__decap_4
XFILLER_0_67_390 VGND VGND VPWR VPWR sky130_fd_sc_hd__fill_2
X_3742_ _0851_ _0849_ _0850_ VGND VGND VPWR VPWR _0854_ sky130_fd_sc_hd__and3_2
XFILLER_0_6_148 VGND VGND VPWR VPWR sky130_fd_sc_hd__decap_8
XFILLER_0_15_449 VPWR VGND VPWR VGND sky130_ef_sc_hd__decap_12
X_3673_ _0208_ _0433_ _0780_ _0781_ VGND VGND VPWR VPWR _0782_ sky130_fd_sc_hd__and4_1
X_2624_ _1794_ _1795_ _1803_ VGND VGND VPWR VPWR _1804_ sky130_fd_sc_hd__o21ai_1
XFILLER_0_2_365 VPWR VGND VPWR VGND sky130_ef_sc_hd__decap_12
XFILLER_0_10_132 VGND VGND VPWR VPWR sky130_fd_sc_hd__decap_8
XFILLER_0_2_398 VPWR VGND VPWR VGND sky130_ef_sc_hd__decap_12
X_2555_ _1719_ _1736_ VGND VGND VPWR VPWR _1737_ sky130_fd_sc_hd__xnor2_1
X_2486_ net26 VGND VGND VPWR VPWR _1671_ sky130_fd_sc_hd__buf_6
X_4225_ _1282_ _1375_ VGND VGND VPWR VPWR _1376_ sky130_fd_sc_hd__xnor2_1
X_4156_ _1183_ _1250_ _1301_ VGND VGND VPWR VPWR _1302_ sky130_fd_sc_hd__or3_1
X_3107_ _0220_ net85 _0151_ _0152_ VGND VGND VPWR VPWR _0223_ sky130_fd_sc_hd__o211ai_2
X_4087_ _1226_ _1227_ VGND VGND VPWR VPWR _1228_ sky130_fd_sc_hd__or2_1
X_3038_ _0097_ _0105_ VGND VGND VPWR VPWR _0154_ sky130_fd_sc_hd__or2b_1
XFILLER_0_65_305 VGND VGND VPWR VPWR sky130_fd_sc_hd__decap_4
XFILLER_0_18_265 VGND VGND VPWR VPWR sky130_fd_sc_hd__decap_3
XFILLER_0_73_371 VPWR VGND VPWR VGND sky130_ef_sc_hd__decap_12
XFILLER_0_73_393 VPWR VGND VPWR VGND sky130_ef_sc_hd__decap_12
XFILLER_0_14_460 VGND VGND VPWR VPWR sky130_fd_sc_hd__decap_3
XFILLER_0_17_29 VPWR VGND VPWR VGND sky130_ef_sc_hd__decap_12
XFILLER_0_68_121 VGND VGND VPWR VPWR sky130_fd_sc_hd__fill_1
XFILLER_0_56_305 VGND VGND VPWR VPWR sky130_fd_sc_hd__decap_3
Xinput26 in_b[1] VGND VGND VPWR VPWR net26 sky130_fd_sc_hd__buf_4
Xinput15 in_a[6] VGND VGND VPWR VPWR net15 sky130_fd_sc_hd__clkbuf_2
X_2340_ _0994_ _1351_ VGND VGND VPWR VPWR _1550_ sky130_fd_sc_hd__nor2_1
XFILLER_0_58_69 VPWR VGND VPWR VGND sky130_ef_sc_hd__decap_12
X_2271_ _1488_ _1492_ VGND VGND VPWR VPWR _1493_ sky130_fd_sc_hd__nand2_1
X_4010_ _1140_ _1142_ _1143_ VGND VGND VPWR VPWR _1144_ sky130_fd_sc_hd__o21ai_1
XFILLER_0_28_9 VGND VGND VPWR VPWR sky130_fd_sc_hd__fill_1
XFILLER_0_74_113 VGND VGND VPWR VPWR sky130_fd_sc_hd__decap_4
XFILLER_0_74_124 VGND VGND VPWR VPWR sky130_fd_sc_hd__fill_2
XFILLER_0_7_457 VGND VGND VPWR VPWR sky130_fd_sc_hd__fill_2
XFILLER_0_62_319 VGND VGND VPWR VPWR sky130_fd_sc_hd__fill_1
X_3725_ _0460_ _2036_ _0430_ _0342_ VGND VGND VPWR VPWR _0835_ sky130_fd_sc_hd__nand4_2
XFILLER_0_55_393 VPWR VGND VPWR VGND sky130_ef_sc_hd__decap_12
XFILLER_0_15_279 VGND VGND VPWR VPWR sky130_fd_sc_hd__fill_1
X_3656_ _0357_ _0156_ _0159_ _0290_ VGND VGND VPWR VPWR _0765_ sky130_fd_sc_hd__a22oi_1
XFILLER_0_11_441 VGND VGND VPWR VPWR sky130_fd_sc_hd__decap_6
X_2607_ net30 VGND VGND VPWR VPWR _1787_ sky130_fd_sc_hd__buf_2
X_3587_ _0678_ _0696_ VGND VGND VPWR VPWR _0697_ sky130_fd_sc_hd__xor2_2
X_2538_ net26 VGND VGND VPWR VPWR _1720_ sky130_fd_sc_hd__buf_6
X_4208_ _1355_ _1357_ VGND VGND VPWR VPWR _1358_ sky130_fd_sc_hd__xnor2_1
X_2469_ _1654_ VGND VGND VPWR VPWR _1655_ sky130_fd_sc_hd__clkbuf_2
X_4139_ _1242_ VGND VGND VPWR VPWR _1283_ sky130_fd_sc_hd__clkbuf_2
XFILLER_0_3_82 VGND VGND VPWR VPWR sky130_fd_sc_hd__fill_1
XFILLER_0_65_113 VPWR VGND VPWR VGND sky130_ef_sc_hd__decap_12
XFILLER_0_46_360 VGND VGND VPWR VPWR sky130_fd_sc_hd__decap_4
XFILLER_0_53_308 VGND VGND VPWR VPWR sky130_fd_sc_hd__decap_8
XFILLER_0_46_382 VPWR VGND VPWR VGND sky130_ef_sc_hd__decap_12
XFILLER_0_61_341 VGND VGND VPWR VPWR sky130_fd_sc_hd__fill_1
XFILLER_0_21_238 VPWR VGND VPWR VGND sky130_ef_sc_hd__decap_12
XFILLER_0_29_305 VGND VGND VPWR VPWR sky130_fd_sc_hd__decap_6
XFILLER_0_29_349 VGND VGND VPWR VPWR sky130_fd_sc_hd__decap_8
XFILLER_0_60_15 VGND VGND VPWR VPWR sky130_fd_sc_hd__decap_3
Xclkbuf_3_4__f_clk clknet_0_clk VGND VGND VPWR VPWR clknet_3_4__leaf_clk sky130_fd_sc_hd__clkbuf_16
XFILLER_0_56_179 VPWR VGND VPWR VGND sky130_ef_sc_hd__decap_12
XFILLER_0_37_382 VGND VGND VPWR VPWR sky130_fd_sc_hd__fill_2
XFILLER_0_8_27 VGND VGND VPWR VPWR sky130_fd_sc_hd__fill_1
X_3510_ _0614_ _0615_ _0620_ VGND VGND VPWR VPWR _0621_ sky130_fd_sc_hd__a21oi_1
XFILLER_0_69_57 VPWR VGND VPWR VGND sky130_ef_sc_hd__decap_12
XFILLER_0_12_249 VGND VGND VPWR VPWR sky130_fd_sc_hd__decap_3
X_3441_ _0551_ _0552_ VGND VGND VPWR VPWR _0553_ sky130_fd_sc_hd__or2b_1
X_3372_ _0483_ _0484_ VGND VGND VPWR VPWR _0485_ sky130_fd_sc_hd__nor2_1
X_2323_ _1501_ VGND VGND VPWR VPWR _1536_ sky130_fd_sc_hd__clkbuf_2
X_2254_ _1470_ _1473_ _1474_ _1477_ VGND VGND VPWR VPWR _1478_ sky130_fd_sc_hd__a211o_1
XFILLER_0_18_72 VPWR VGND VPWR VGND sky130_ef_sc_hd__decap_12
X_2185_ net46 add_tmp\[19\] VGND VGND VPWR VPWR _1409_ sky130_fd_sc_hd__or2_1
XFILLER_0_47_113 VGND VGND VPWR VPWR sky130_fd_sc_hd__decap_3
XFILLER_0_75_433 VPWR VGND VPWR VGND sky130_ef_sc_hd__decap_12
XFILLER_0_7_210 VGND VGND VPWR VPWR sky130_fd_sc_hd__fill_2
XFILLER_0_43_352 VPWR VGND VPWR VGND sky130_ef_sc_hd__decap_12
X_3708_ _0811_ _0815_ VGND VGND VPWR VPWR _0817_ sky130_fd_sc_hd__nand2_1
X_3639_ _0289_ _0747_ VGND VGND VPWR VPWR _0748_ sky130_fd_sc_hd__nor2_1
XFILLER_0_38_135 VGND VGND VPWR VPWR sky130_fd_sc_hd__fill_1
XFILLER_0_66_433 VPWR VGND VPWR VGND sky130_ef_sc_hd__decap_12
XFILLER_0_19_393 VGND VGND VPWR VPWR sky130_fd_sc_hd__decap_6
XFILLER_0_30_29 VPWR VGND VPWR VGND sky130_ef_sc_hd__decap_12
XFILLER_0_34_363 VGND VGND VPWR VPWR sky130_fd_sc_hd__fill_1
XTAP_219 VGND VPWR sky130_fd_sc_hd__tapvpwrvgnd_1
XTAP_208 VGND VPWR sky130_fd_sc_hd__tapvpwrvgnd_1
XFILLER_0_55_26 VPWR VGND VPWR VGND sky130_ef_sc_hd__decap_12
XFILLER_0_76_219 VGND VGND VPWR VPWR sky130_fd_sc_hd__decap_8
X_3990_ _1109_ _1057_ VGND VGND VPWR VPWR _1122_ sky130_fd_sc_hd__and2b_1
XFILLER_0_29_113 VPWR VGND VPWR VGND sky130_ef_sc_hd__decap_12
X_2941_ _2113_ _2114_ net109 _2056_ VGND VGND VPWR VPWR _2116_ sky130_fd_sc_hd__o211ai_2
XFILLER_0_44_116 VGND VGND VPWR VPWR sky130_fd_sc_hd__fill_1
X_2872_ net117 _2047_ VGND VGND VPWR VPWR _2048_ sky130_fd_sc_hd__or2b_4
XFILLER_0_25_385 VGND VGND VPWR VPWR sky130_fd_sc_hd__decap_6
XFILLER_0_52_193 VGND VGND VPWR VPWR sky130_fd_sc_hd__decap_3
X_3424_ _0268_ VGND VGND VPWR VPWR _0536_ sky130_fd_sc_hd__clkbuf_2
XFILLER_0_29_60 VPWR VGND VPWR VGND sky130_ef_sc_hd__decap_12
X_3355_ _0465_ _0466_ _0467_ VGND VGND VPWR VPWR _0468_ sky130_fd_sc_hd__nand3_1
XTAP_720 VGND VPWR sky130_fd_sc_hd__tapvpwrvgnd_1
XTAP_731 VGND VPWR sky130_fd_sc_hd__tapvpwrvgnd_1
XTAP_742 VGND VPWR sky130_fd_sc_hd__tapvpwrvgnd_1
XTAP_786 VGND VPWR sky130_fd_sc_hd__tapvpwrvgnd_1
XTAP_775 VGND VPWR sky130_fd_sc_hd__tapvpwrvgnd_1
XTAP_764 VGND VPWR sky130_fd_sc_hd__tapvpwrvgnd_1
X_2306_ _1521_ add_tmp\[5\] _1522_ VGND VGND VPWR VPWR _1523_ sky130_fd_sc_hd__mux2_1
X_3286_ _1670_ _0398_ net151 _0244_ VGND VGND VPWR VPWR _0400_ sky130_fd_sc_hd__a211o_1
XTAP_753 VGND VPWR sky130_fd_sc_hd__tapvpwrvgnd_1
X_2237_ _1459_ _1460_ VGND VGND VPWR VPWR _1461_ sky130_fd_sc_hd__nand2_1
X_2168_ net69 add_tmp\[7\] VGND VGND VPWR VPWR _1265_ sky130_fd_sc_hd__and2_1
XFILLER_0_48_433 VGND VGND VPWR VPWR sky130_fd_sc_hd__decap_4
XFILLER_0_0_72 VPWR VGND VPWR VGND sky130_ef_sc_hd__decap_12
XFILLER_0_61_80 VPWR VGND VPWR VGND sky130_ef_sc_hd__decap_12
XFILLER_0_63_447 VGND VGND VPWR VPWR sky130_fd_sc_hd__fill_1
XFILLER_0_16_385 VGND VGND VPWR VPWR sky130_fd_sc_hd__fill_2
XFILLER_0_41_108 VGND VGND VPWR VPWR sky130_fd_sc_hd__decap_4
XFILLER_0_34_171 VGND VGND VPWR VPWR sky130_fd_sc_hd__fill_1
XFILLER_0_22_377 VPWR VGND VPWR VGND sky130_ef_sc_hd__decap_12
X_3140_ net114 _0169_ VGND VGND VPWR VPWR _0255_ sky130_fd_sc_hd__or2_4
X_3071_ _0185_ _0182_ _0184_ VGND VGND VPWR VPWR _0187_ sky130_fd_sc_hd__nand3_1
XFILLER_0_15_51 VGND VGND VPWR VPWR sky130_fd_sc_hd__decap_4
X_3973_ _1094_ _1095_ _1104_ VGND VGND VPWR VPWR _1105_ sky130_fd_sc_hd__o21a_1
XFILLER_0_17_116 VPWR VGND VPWR VGND sky130_ef_sc_hd__decap_12
X_2924_ _2095_ _2097_ _2091_ VGND VGND VPWR VPWR _2099_ sky130_fd_sc_hd__a21o_1
XFILLER_0_45_447 VGND VGND VPWR VPWR sky130_fd_sc_hd__fill_1
X_2855_ _1952_ _1968_ _2029_ _2030_ VGND VGND VPWR VPWR _2031_ sky130_fd_sc_hd__a211o_1
XFILLER_0_60_417 VGND VGND VPWR VPWR sky130_fd_sc_hd__decap_3
XFILLER_0_72_277 VGND VGND VPWR VPWR sky130_fd_sc_hd__decap_4
XFILLER_0_72_288 VGND VGND VPWR VPWR sky130_fd_sc_hd__fill_1
X_2786_ _1667_ _1962_ VGND VGND VPWR VPWR _1963_ sky130_fd_sc_hd__nand2_1
XFILLER_0_40_174 VGND VGND VPWR VPWR sky130_fd_sc_hd__fill_1
XFILLER_0_0_271 VGND VGND VPWR VPWR sky130_fd_sc_hd__decap_4
X_3407_ _0398_ VGND VGND VPWR VPWR _0519_ sky130_fd_sc_hd__clkbuf_2
XFILLER_0_0_293 VPWR VGND VPWR VGND sky130_ef_sc_hd__decap_12
XTAP_550 VGND VPWR sky130_fd_sc_hd__tapvpwrvgnd_1
XTAP_561 VGND VPWR sky130_fd_sc_hd__tapvpwrvgnd_1
X_3338_ _0444_ _0448_ _0450_ VGND VGND VPWR VPWR _0451_ sky130_fd_sc_hd__and3_1
XTAP_572 VGND VPWR sky130_fd_sc_hd__tapvpwrvgnd_1
XTAP_583 VGND VPWR sky130_fd_sc_hd__tapvpwrvgnd_1
XTAP_594 VGND VPWR sky130_fd_sc_hd__tapvpwrvgnd_1
X_3269_ _0079_ _0381_ _0382_ VGND VGND VPWR VPWR _0383_ sky130_fd_sc_hd__a21bo_1
XFILLER_0_56_80 VGND VGND VPWR VPWR sky130_fd_sc_hd__decap_4
XFILLER_0_36_425 VGND VGND VPWR VPWR sky130_fd_sc_hd__decap_6
XFILLER_0_48_274 VPWR VGND VPWR VGND sky130_ef_sc_hd__decap_12
XFILLER_0_16_160 VPWR VGND VPWR VGND sky130_ef_sc_hd__decap_12
XFILLER_0_8_393 VPWR VGND VPWR VGND sky130_ef_sc_hd__decap_12
XFILLER_0_51_428 VPWR VGND VPWR VGND sky130_ef_sc_hd__decap_12
XFILLER_0_31_130 VPWR VGND VPWR VGND sky130_ef_sc_hd__decap_12
XFILLER_0_39_241 VGND VGND VPWR VPWR sky130_fd_sc_hd__decap_8
X_2640_ _1668_ _1800_ _1818_ _1796_ VGND VGND VPWR VPWR _1819_ sky130_fd_sc_hd__a22oi_2
XFILLER_0_42_428 VPWR VGND VPWR VGND sky130_ef_sc_hd__decap_12
XFILLER_0_22_141 VGND VGND VPWR VPWR sky130_fd_sc_hd__decap_3
X_2571_ net11 VGND VGND VPWR VPWR _1752_ sky130_fd_sc_hd__clkbuf_2
XFILLER_0_50_450 VGND VGND VPWR VPWR sky130_fd_sc_hd__decap_3
XFILLER_0_77_35 VPWR VGND VPWR VGND sky130_ef_sc_hd__decap_12
X_4310_ clknet_3_4__leaf_clk _0055_ net35 VGND VGND VPWR VPWR add_tmp\[17\] sky130_fd_sc_hd__dfrtp_1
XFILLER_0_77_79 VGND VGND VPWR VPWR sky130_fd_sc_hd__fill_1
X_4241_ _1388_ _1389_ VGND VGND VPWR VPWR _1392_ sky130_fd_sc_hd__or2b_1
X_4172_ _1278_ _1279_ _1318_ VGND VGND VPWR VPWR _1320_ sky130_fd_sc_hd__a21o_1
X_3123_ _0236_ _0237_ VGND VGND VPWR VPWR _0238_ sky130_fd_sc_hd__and2_1
X_3054_ _0168_ _0169_ VGND VGND VPWR VPWR _0170_ sky130_fd_sc_hd__nor2_2
XFILLER_0_9_113 VGND VGND VPWR VPWR sky130_fd_sc_hd__decap_4
XFILLER_0_9_102 VGND VGND VPWR VPWR sky130_fd_sc_hd__fill_1
XFILLER_0_18_414 VGND VGND VPWR VPWR sky130_fd_sc_hd__fill_1
X_3956_ _0996_ _0998_ _1084_ VGND VGND VPWR VPWR _1086_ sky130_fd_sc_hd__and3_1
XFILLER_0_45_233 VGND VGND VPWR VPWR sky130_fd_sc_hd__decap_3
X_2907_ _2079_ _2080_ _2074_ VGND VGND VPWR VPWR _2082_ sky130_fd_sc_hd__a21oi_1
X_3887_ _0088_ _0342_ VGND VGND VPWR VPWR _1011_ sky130_fd_sc_hd__and2_1
X_2838_ _2009_ _2013_ VGND VGND VPWR VPWR _2014_ sky130_fd_sc_hd__xnor2_2
XFILLER_0_13_152 VPWR VGND VPWR VGND sky130_ef_sc_hd__decap_12
XFILLER_0_41_461 VGND VGND VPWR VPWR sky130_fd_sc_hd__fill_2
X_2769_ _1865_ _1871_ _1869_ VGND VGND VPWR VPWR _1946_ sky130_fd_sc_hd__a21bo_1
XTAP_380 VGND VPWR sky130_fd_sc_hd__tapvpwrvgnd_1
XTAP_391 VGND VPWR sky130_fd_sc_hd__tapvpwrvgnd_1
XPHY_31 VGND VGND VPWR VPWR sky130_fd_sc_hd__decap_3
XPHY_20 VGND VGND VPWR VPWR sky130_fd_sc_hd__decap_3
Xrebuffer60 _0314_ VGND VGND VPWR VPWR net146 sky130_fd_sc_hd__dlygate4sd1_1
XPHY_42 VGND VGND VPWR VPWR sky130_fd_sc_hd__decap_3
XPHY_53 VGND VGND VPWR VPWR sky130_fd_sc_hd__decap_3
XPHY_64 VGND VGND VPWR VPWR sky130_fd_sc_hd__decap_3
XFILLER_0_76_380 VGND VGND VPWR VPWR sky130_fd_sc_hd__decap_4
XPHY_75 VGND VGND VPWR VPWR sky130_fd_sc_hd__decap_3
XPHY_86 VGND VGND VPWR VPWR sky130_fd_sc_hd__decap_3
XPHY_97 VGND VGND VPWR VPWR sky130_fd_sc_hd__decap_3
XFILLER_0_51_269 VGND VGND VPWR VPWR sky130_fd_sc_hd__fill_1
XFILLER_0_2_29 VPWR VGND VPWR VGND sky130_ef_sc_hd__decap_12
XFILLER_0_63_15 VPWR VGND VPWR VGND sky130_ef_sc_hd__decap_12
XFILLER_0_59_347 VGND VGND VPWR VPWR sky130_fd_sc_hd__decap_4
XFILLER_0_59_358 VPWR VGND VPWR VGND sky130_ef_sc_hd__decap_12
X_3810_ _0925_ _0919_ _0920_ VGND VGND VPWR VPWR _0927_ sky130_fd_sc_hd__nand3_2
X_3741_ _0849_ _0850_ _0851_ VGND VGND VPWR VPWR _0852_ sky130_fd_sc_hd__a21oi_2
XFILLER_0_6_116 VPWR VGND VPWR VGND sky130_ef_sc_hd__decap_12
X_3672_ _0100_ _1817_ _0267_ _0268_ VGND VGND VPWR VPWR _0781_ sky130_fd_sc_hd__nand4_1
X_2623_ _1801_ _1802_ VGND VGND VPWR VPWR _1803_ sky130_fd_sc_hd__or2_1
XFILLER_0_42_269 VGND VGND VPWR VPWR sky130_fd_sc_hd__decap_8
XFILLER_0_23_461 VGND VGND VPWR VPWR sky130_fd_sc_hd__fill_2
X_2554_ _1734_ _1735_ VGND VGND VPWR VPWR _1736_ sky130_fd_sc_hd__and2b_1
XFILLER_0_50_291 VPWR VGND VPWR VGND sky130_ef_sc_hd__decap_12
X_2485_ _1669_ VGND VGND VPWR VPWR _1670_ sky130_fd_sc_hd__clkbuf_2
X_4224_ _1338_ _1374_ VGND VGND VPWR VPWR _1375_ sky130_fd_sc_hd__xnor2_1
X_4155_ _1299_ _1300_ VGND VGND VPWR VPWR _1301_ sky130_fd_sc_hd__nor2_1
X_3106_ _0151_ _0152_ _0220_ net86 VGND VGND VPWR VPWR _0222_ sky130_fd_sc_hd__a211o_1
X_4086_ _1170_ _1171_ _1225_ VGND VGND VPWR VPWR _1227_ sky130_fd_sc_hd__nor3_1
X_3037_ _0098_ _0104_ VGND VGND VPWR VPWR _0153_ sky130_fd_sc_hd__nand2_1
XFILLER_0_18_211 VPWR VGND VPWR VGND sky130_ef_sc_hd__decap_12
X_3939_ _1065_ _1066_ VGND VGND VPWR VPWR _1067_ sky130_fd_sc_hd__xor2_1
XFILLER_0_33_225 VGND VGND VPWR VPWR sky130_fd_sc_hd__decap_8
XFILLER_0_73_383 VGND VGND VPWR VPWR sky130_fd_sc_hd__decap_8
XFILLER_0_33_258 VPWR VGND VPWR VGND sky130_ef_sc_hd__decap_12
XFILLER_0_68_166 VGND VGND VPWR VPWR sky130_fd_sc_hd__decap_3
XFILLER_0_49_391 VGND VGND VPWR VPWR sky130_fd_sc_hd__fill_1
Xinput27 in_b[2] VGND VGND VPWR VPWR net27 sky130_fd_sc_hd__buf_4
Xinput16 in_a[7] VGND VGND VPWR VPWR net16 sky130_fd_sc_hd__clkbuf_2
XFILLER_0_3_108 VGND VGND VPWR VPWR sky130_fd_sc_hd__decap_4
XFILLER_0_24_258 VPWR VGND VPWR VGND sky130_ef_sc_hd__decap_12
XFILLER_0_58_15 VPWR VGND VPWR VGND sky130_ef_sc_hd__decap_12
X_2270_ en_delay VGND VGND VPWR VPWR _1492_ sky130_fd_sc_hd__clkbuf_2
XFILLER_0_47_328 VGND VGND VPWR VPWR sky130_fd_sc_hd__fill_1
XFILLER_0_59_177 VGND VGND VPWR VPWR sky130_fd_sc_hd__fill_2
XFILLER_0_55_361 VGND VGND VPWR VPWR sky130_fd_sc_hd__fill_2
XFILLER_0_62_309 VGND VGND VPWR VPWR sky130_fd_sc_hd__fill_1
XFILLER_0_15_225 VPWR VGND VPWR VGND sky130_ef_sc_hd__decap_12
X_3724_ _0083_ _0278_ _0118_ _1973_ VGND VGND VPWR VPWR _0834_ sky130_fd_sc_hd__a22o_1
X_3655_ _0760_ _0762_ _0754_ _0756_ VGND VGND VPWR VPWR _0764_ sky130_fd_sc_hd__a211o_1
X_2606_ _1784_ _1785_ VGND VGND VPWR VPWR _1786_ sky130_fd_sc_hd__nor2_1
XFILLER_0_2_141 VGND VGND VPWR VPWR sky130_fd_sc_hd__decap_4
XFILLER_0_30_239 VGND VGND VPWR VPWR sky130_fd_sc_hd__fill_2
X_3586_ _0694_ _0695_ VGND VGND VPWR VPWR _0696_ sky130_fd_sc_hd__nor2_1
X_2537_ _1717_ _1718_ VGND VGND VPWR VPWR _1719_ sky130_fd_sc_hd__nor2_1
XFILLER_0_54_3 VPWR VGND VPWR VGND sky130_ef_sc_hd__decap_12
X_2468_ net2 VGND VGND VPWR VPWR _1654_ sky130_fd_sc_hd__inv_2
X_4207_ _1258_ _1311_ _1356_ VGND VGND VPWR VPWR _1357_ sky130_fd_sc_hd__a21bo_1
X_2399_ _1598_ VGND VGND VPWR VPWR _0024_ sky130_fd_sc_hd__clkbuf_1
X_4138_ _1184_ VGND VGND VPWR VPWR _1282_ sky130_fd_sc_hd__clkbuf_2
X_4069_ _1161_ _1160_ VGND VGND VPWR VPWR _1208_ sky130_fd_sc_hd__and2b_1
XFILLER_0_65_125 VGND VGND VPWR VPWR sky130_fd_sc_hd__decap_4
XFILLER_0_65_169 VPWR VGND VPWR VGND sky130_ef_sc_hd__decap_12
XFILLER_0_46_394 VGND VGND VPWR VPWR sky130_fd_sc_hd__decap_8
XFILLER_0_61_331 VGND VGND VPWR VPWR sky130_fd_sc_hd__decap_4
XFILLER_0_73_191 VPWR VGND VPWR VGND sky130_ef_sc_hd__decap_12
XFILLER_0_28_29 VGND VGND VPWR VPWR sky130_fd_sc_hd__decap_8
XFILLER_0_60_27 VGND VGND VPWR VPWR sky130_fd_sc_hd__fill_1
XFILLER_0_44_309 VGND VGND VPWR VPWR sky130_fd_sc_hd__decap_6
XFILLER_0_4_406 VPWR VGND VPWR VGND sky130_ef_sc_hd__decap_12
XFILLER_0_52_353 VGND VGND VPWR VPWR sky130_fd_sc_hd__decap_8
X_3440_ _0549_ _0550_ _0546_ VGND VGND VPWR VPWR _0552_ sky130_fd_sc_hd__a21o_1
XFILLER_0_69_69 VPWR VGND VPWR VGND sky130_ef_sc_hd__decap_12
X_3371_ _0378_ _0386_ _0481_ _0482_ VGND VGND VPWR VPWR _0484_ sky130_fd_sc_hd__a211oi_2
XFILLER_0_20_261 VGND VGND VPWR VPWR sky130_fd_sc_hd__fill_2
X_2322_ net70 _1502_ _1504_ net140 _1535_ VGND VGND VPWR VPWR _0010_ sky130_fd_sc_hd__a221o_1
X_2253_ _1475_ _1476_ VGND VGND VPWR VPWR _1477_ sky130_fd_sc_hd__nand2_1
X_2184_ net46 add_tmp\[19\] VGND VGND VPWR VPWR _1408_ sky130_fd_sc_hd__nand2_1
XFILLER_0_75_445 VGND VGND VPWR VPWR sky130_fd_sc_hd__decap_3
XFILLER_0_47_169 VGND VGND VPWR VPWR sky130_fd_sc_hd__decap_6
XFILLER_0_28_394 VGND VGND VPWR VPWR sky130_fd_sc_hd__fill_2
XFILLER_0_62_139 VGND VGND VPWR VPWR sky130_fd_sc_hd__fill_1
XFILLER_0_43_364 VPWR VGND VPWR VGND sky130_ef_sc_hd__decap_12
X_3707_ _0811_ _0815_ VGND VGND VPWR VPWR _0816_ sky130_fd_sc_hd__or2_2
XFILLER_0_3_461 VGND VGND VPWR VPWR sky130_fd_sc_hd__fill_2
X_3638_ _0402_ VGND VGND VPWR VPWR _0747_ sky130_fd_sc_hd__clkbuf_2
X_3569_ _0627_ _0636_ _0635_ VGND VGND VPWR VPWR _0679_ sky130_fd_sc_hd__a21o_1
XFILLER_0_38_114 VGND VGND VPWR VPWR sky130_fd_sc_hd__decap_6
XFILLER_0_66_445 VPWR VGND VPWR VGND sky130_ef_sc_hd__decap_12
XFILLER_0_61_183 VGND VGND VPWR VPWR sky130_fd_sc_hd__decap_8
XTAP_209 VGND VPWR sky130_fd_sc_hd__tapvpwrvgnd_1
XFILLER_0_71_37 VGND VGND VPWR VPWR sky130_fd_sc_hd__fill_1
XFILLER_0_29_125 VGND VGND VPWR VPWR sky130_fd_sc_hd__decap_3
XFILLER_0_29_136 VGND VGND VPWR VPWR sky130_fd_sc_hd__fill_1
X_2940_ net109 _2056_ _2113_ _2114_ VGND VGND VPWR VPWR _2115_ sky130_fd_sc_hd__a211o_1
XFILLER_0_29_169 VPWR VGND VPWR VGND sky130_ef_sc_hd__decap_12
X_2871_ _2044_ _2045_ _1969_ _1979_ VGND VGND VPWR VPWR _2047_ sky130_fd_sc_hd__o211ai_1
XFILLER_0_44_128 VGND VGND VPWR VPWR sky130_fd_sc_hd__fill_1
XFILLER_0_44_139 VGND VGND VPWR VPWR sky130_fd_sc_hd__fill_1
XFILLER_0_4_269 VPWR VGND VPWR VGND sky130_ef_sc_hd__decap_12
X_3423_ _1956_ _0534_ VGND VGND VPWR VPWR _0535_ sky130_fd_sc_hd__nand2_1
XTAP_710 VGND VPWR sky130_fd_sc_hd__tapvpwrvgnd_1
X_3354_ _0372_ _0368_ _0370_ VGND VGND VPWR VPWR _0467_ sky130_fd_sc_hd__a21bo_1
XTAP_721 VGND VPWR sky130_fd_sc_hd__tapvpwrvgnd_1
XTAP_732 VGND VPWR sky130_fd_sc_hd__tapvpwrvgnd_1
XTAP_743 VGND VPWR sky130_fd_sc_hd__tapvpwrvgnd_1
XTAP_776 VGND VPWR sky130_fd_sc_hd__tapvpwrvgnd_1
XTAP_765 VGND VPWR sky130_fd_sc_hd__tapvpwrvgnd_1
XFILLER_0_29_72 VGND VGND VPWR VPWR sky130_fd_sc_hd__fill_1
X_3285_ net151 _0244_ _1670_ _0398_ VGND VGND VPWR VPWR _0399_ sky130_fd_sc_hd__o211a_1
X_2305_ _1487_ VGND VGND VPWR VPWR _1522_ sky130_fd_sc_hd__buf_2
XTAP_754 VGND VPWR sky130_fd_sc_hd__tapvpwrvgnd_1
XTAP_787 VGND VPWR sky130_fd_sc_hd__tapvpwrvgnd_1
X_2236_ net60 add_tmp\[31\] VGND VGND VPWR VPWR _1460_ sky130_fd_sc_hd__or2_1
X_2167_ _1059_ _1232_ _1243_ VGND VGND VPWR VPWR _1254_ sky130_fd_sc_hd__o21a_1
XFILLER_0_61_92 VGND VGND VPWR VPWR sky130_fd_sc_hd__decap_3
XFILLER_0_63_426 VGND VGND VPWR VPWR sky130_fd_sc_hd__decap_6
XFILLER_0_58_209 VPWR VGND VPWR VGND sky130_ef_sc_hd__decap_12
XFILLER_0_54_404 VGND VGND VPWR VPWR sky130_fd_sc_hd__decap_8
XFILLER_0_54_437 VGND VGND VPWR VPWR sky130_fd_sc_hd__decap_3
XFILLER_0_22_301 VGND VGND VPWR VPWR sky130_fd_sc_hd__decap_6
XFILLER_0_22_389 VGND VGND VPWR VPWR sky130_fd_sc_hd__decap_4
X_3070_ _0182_ _0184_ _0185_ VGND VGND VPWR VPWR _0186_ sky130_fd_sc_hd__a21o_1
X_3972_ _1034_ _1102_ VGND VGND VPWR VPWR _1104_ sky130_fd_sc_hd__xnor2_1
XFILLER_0_57_253 VGND VGND VPWR VPWR sky130_fd_sc_hd__fill_1
XFILLER_0_17_128 VPWR VGND VPWR VGND sky130_ef_sc_hd__decap_12
X_2923_ _2091_ _2095_ _2097_ VGND VGND VPWR VPWR _2098_ sky130_fd_sc_hd__nand3_1
XFILLER_0_31_51 VGND VGND VPWR VPWR sky130_fd_sc_hd__fill_1
X_2854_ _2027_ _2028_ net75 VGND VGND VPWR VPWR _2030_ sky130_fd_sc_hd__a21oi_1
XFILLER_0_31_84 VGND VGND VPWR VPWR sky130_fd_sc_hd__decap_8
X_2785_ _1894_ VGND VGND VPWR VPWR _1962_ sky130_fd_sc_hd__buf_2
XFILLER_0_40_197 VGND VGND VPWR VPWR sky130_fd_sc_hd__decap_8
X_3406_ _1681_ _0517_ _0474_ VGND VGND VPWR VPWR _0518_ sky130_fd_sc_hd__and3b_2
XTAP_540 VGND VPWR sky130_fd_sc_hd__tapvpwrvgnd_1
XTAP_551 VGND VPWR sky130_fd_sc_hd__tapvpwrvgnd_1
X_3337_ _0357_ _0449_ _0446_ _0447_ VGND VGND VPWR VPWR _0450_ sky130_fd_sc_hd__nand4_2
XTAP_562 VGND VPWR sky130_fd_sc_hd__tapvpwrvgnd_1
XTAP_573 VGND VPWR sky130_fd_sc_hd__tapvpwrvgnd_1
XTAP_584 VGND VPWR sky130_fd_sc_hd__tapvpwrvgnd_1
X_3268_ _1927_ _0088_ _0155_ _1877_ VGND VGND VPWR VPWR _0382_ sky130_fd_sc_hd__a22o_1
XTAP_595 VGND VPWR sky130_fd_sc_hd__tapvpwrvgnd_1
X_2219_ _1441_ _1442_ VGND VGND VPWR VPWR _1443_ sky130_fd_sc_hd__nand2_1
X_3199_ _0229_ _0313_ VGND VGND VPWR VPWR _0314_ sky130_fd_sc_hd__xor2_2
XFILLER_0_48_286 VPWR VGND VPWR VGND sky130_ef_sc_hd__decap_12
XFILLER_0_63_223 VGND VGND VPWR VPWR sky130_fd_sc_hd__fill_1
XFILLER_0_63_234 VPWR VGND VPWR VGND sky130_ef_sc_hd__decap_12
XFILLER_0_63_278 VGND VGND VPWR VPWR sky130_fd_sc_hd__fill_2
XFILLER_0_16_172 VPWR VGND VPWR VGND sky130_ef_sc_hd__decap_12
XFILLER_0_31_142 VGND VGND VPWR VPWR sky130_fd_sc_hd__fill_1
XFILLER_0_6_3 VPWR VGND VPWR VGND sky130_ef_sc_hd__decap_12
XFILLER_0_36_29 VGND VGND VPWR VPWR sky130_fd_sc_hd__decap_4
XFILLER_0_52_17 VGND VGND VPWR VPWR sky130_fd_sc_hd__decap_8
XFILLER_0_39_286 VGND VGND VPWR VPWR sky130_fd_sc_hd__decap_6
XFILLER_0_6_309 VPWR VGND VPWR VGND sky130_ef_sc_hd__decap_12
XFILLER_0_14_109 VPWR VGND VPWR VGND sky130_ef_sc_hd__decap_12
XFILLER_0_54_267 VPWR VGND VPWR VGND sky130_ef_sc_hd__decap_12
X_2570_ _1747_ _1748_ _1749_ VGND VGND VPWR VPWR _1751_ sky130_fd_sc_hd__a21o_1
XFILLER_0_22_164 VGND VGND VPWR VPWR sky130_fd_sc_hd__decap_6
XFILLER_0_77_47 VGND VGND VPWR VPWR sky130_fd_sc_hd__decap_8
X_4240_ _1391_ VGND VGND VPWR VPWR _0068_ sky130_fd_sc_hd__clkbuf_1
X_4171_ _1316_ _1317_ VGND VGND VPWR VPWR _1318_ sky130_fd_sc_hd__xor2_1
X_3122_ _0162_ _0174_ _0179_ VGND VGND VPWR VPWR _0237_ sky130_fd_sc_hd__or3_1
X_3053_ _0166_ _0167_ _1679_ _0088_ VGND VGND VPWR VPWR _0169_ sky130_fd_sc_hd__and4bb_1
XFILLER_0_77_337 VGND VGND VPWR VPWR sky130_fd_sc_hd__decap_8
X_3955_ _0997_ _0998_ _1084_ VGND VGND VPWR VPWR _1085_ sky130_fd_sc_hd__a21oi_1
XFILLER_0_9_169 VPWR VGND VPWR VGND sky130_ef_sc_hd__decap_12
XFILLER_0_42_72 VGND VGND VPWR VPWR sky130_fd_sc_hd__fill_1
X_2906_ _2074_ _2079_ _2080_ VGND VGND VPWR VPWR _2081_ sky130_fd_sc_hd__and3_1
XFILLER_0_5_331 VGND VGND VPWR VPWR sky130_fd_sc_hd__decap_4
X_3886_ _0369_ _0462_ _0857_ _0536_ VGND VGND VPWR VPWR _1010_ sky130_fd_sc_hd__nand4_1
X_2837_ _2011_ _2012_ VGND VGND VPWR VPWR _2013_ sky130_fd_sc_hd__and2b_1
X_2768_ _1941_ _1943_ _1935_ VGND VGND VPWR VPWR _1945_ sky130_fd_sc_hd__a21o_1
XFILLER_0_13_164 VGND VGND VPWR VPWR sky130_fd_sc_hd__decap_4
X_2699_ _1694_ VGND VGND VPWR VPWR _1877_ sky130_fd_sc_hd__clkbuf_2
XTAP_370 VGND VPWR sky130_fd_sc_hd__tapvpwrvgnd_1
XTAP_381 VGND VPWR sky130_fd_sc_hd__tapvpwrvgnd_1
XTAP_392 VGND VPWR sky130_fd_sc_hd__tapvpwrvgnd_1
XPHY_21 VGND VGND VPWR VPWR sky130_fd_sc_hd__decap_3
XPHY_10 VGND VGND VPWR VPWR sky130_fd_sc_hd__decap_3
Xrebuffer50 _0836_ VGND VGND VPWR VPWR net123 sky130_fd_sc_hd__dlygate4sd2_1
Xrebuffer61 _0258_ VGND VGND VPWR VPWR net147 sky130_fd_sc_hd__buf_2
XPHY_32 VGND VGND VPWR VPWR sky130_fd_sc_hd__decap_3
XPHY_43 VGND VGND VPWR VPWR sky130_fd_sc_hd__decap_3
XPHY_54 VGND VGND VPWR VPWR sky130_fd_sc_hd__decap_3
XPHY_65 VGND VGND VPWR VPWR sky130_fd_sc_hd__decap_3
XFILLER_0_36_201 VGND VGND VPWR VPWR sky130_fd_sc_hd__decap_6
XPHY_76 VGND VGND VPWR VPWR sky130_fd_sc_hd__decap_3
XPHY_87 VGND VGND VPWR VPWR sky130_fd_sc_hd__decap_3
XPHY_98 VGND VGND VPWR VPWR sky130_fd_sc_hd__decap_3
XFILLER_0_24_407 VGND VGND VPWR VPWR sky130_fd_sc_hd__decap_6
XFILLER_0_24_429 VGND VGND VPWR VPWR sky130_fd_sc_hd__decap_8
XFILLER_0_63_27 VPWR VGND VPWR VGND sky130_ef_sc_hd__decap_12
XFILLER_0_59_337 VGND VGND VPWR VPWR sky130_fd_sc_hd__decap_6
XFILLER_0_74_307 VGND VGND VPWR VPWR sky130_fd_sc_hd__fill_1
X_3740_ _0763_ _0771_ VGND VGND VPWR VPWR _0851_ sky130_fd_sc_hd__nand2_1
XFILLER_0_12_97 VGND VGND VPWR VPWR sky130_fd_sc_hd__decap_4
X_3671_ _0445_ _0183_ _0268_ _1798_ VGND VGND VPWR VPWR _0780_ sky130_fd_sc_hd__a22o_1
X_2622_ _1662_ _1800_ net127 net94 VGND VGND VPWR VPWR _1802_ sky130_fd_sc_hd__a211oi_1
XFILLER_0_2_345 VGND VGND VPWR VPWR sky130_fd_sc_hd__fill_2
XFILLER_0_2_356 VGND VGND VPWR VPWR sky130_fd_sc_hd__decap_8
X_2553_ _1732_ _1733_ _1698_ _1702_ VGND VGND VPWR VPWR _1735_ sky130_fd_sc_hd__a211o_1
XFILLER_0_10_167 VPWR VGND VPWR VGND sky130_ef_sc_hd__decap_12
X_2484_ _1668_ VGND VGND VPWR VPWR _1669_ sky130_fd_sc_hd__clkbuf_2
X_4223_ _1283_ _1334_ _1236_ VGND VGND VPWR VPWR _1374_ sky130_fd_sc_hd__o21ai_1
X_4154_ _1282_ _1298_ VGND VGND VPWR VPWR _1300_ sky130_fd_sc_hd__nor2_1
X_4085_ _1170_ _1171_ _1225_ VGND VGND VPWR VPWR _1226_ sky130_fd_sc_hd__o21a_1
XFILLER_0_37_72 VGND VGND VPWR VPWR sky130_fd_sc_hd__fill_1
X_3105_ _0178_ _0179_ _0218_ _0219_ VGND VGND VPWR VPWR _0221_ sky130_fd_sc_hd__nor4_4
X_3036_ _0095_ _0134_ _0135_ VGND VGND VPWR VPWR _0152_ sky130_fd_sc_hd__or3_4
XFILLER_0_77_167 VGND VGND VPWR VPWR sky130_fd_sc_hd__fill_1
XFILLER_0_53_82 VGND VGND VPWR VPWR sky130_fd_sc_hd__decap_8
XFILLER_0_65_329 VGND VGND VPWR VPWR sky130_fd_sc_hd__decap_6
XFILLER_0_18_223 VPWR VGND VPWR VGND sky130_ef_sc_hd__decap_12
X_3938_ _0837_ _0476_ VGND VGND VPWR VPWR _1066_ sky130_fd_sc_hd__nand2_1
X_3869_ _0954_ VGND VGND VPWR VPWR _0991_ sky130_fd_sc_hd__inv_2
XFILLER_0_33_215 VGND VGND VPWR VPWR sky130_fd_sc_hd__fill_1
XFILLER_0_41_281 VPWR VGND VPWR VGND sky130_ef_sc_hd__decap_12
Xinput17 in_a[8] VGND VGND VPWR VPWR net17 sky130_fd_sc_hd__buf_4
Xinput28 in_b[3] VGND VGND VPWR VPWR net28 sky130_fd_sc_hd__buf_4
XFILLER_0_64_373 VGND VGND VPWR VPWR sky130_fd_sc_hd__fill_1
XFILLER_0_24_248 VGND VGND VPWR VPWR sky130_fd_sc_hd__decap_4
XFILLER_0_20_421 VGND VGND VPWR VPWR sky130_fd_sc_hd__decap_4
XFILLER_0_58_27 VGND VGND VPWR VPWR sky130_fd_sc_hd__fill_1
XFILLER_0_74_15 VPWR VGND VPWR VGND sky130_ef_sc_hd__decap_12
XFILLER_0_59_167 VGND VGND VPWR VPWR sky130_fd_sc_hd__fill_1
XFILLER_0_7_404 VPWR VGND VPWR VGND sky130_ef_sc_hd__decap_12
X_3723_ _0786_ _0785_ _0784_ VGND VGND VPWR VPWR _0833_ sky130_fd_sc_hd__a21bo_1
XFILLER_0_15_237 VPWR VGND VPWR VGND sky130_ef_sc_hd__decap_12
X_3654_ _0754_ _0756_ _0760_ _0762_ VGND VGND VPWR VPWR _0763_ sky130_fd_sc_hd__o211ai_2
X_2605_ _1729_ _1721_ _1753_ _1715_ VGND VGND VPWR VPWR _1785_ sky130_fd_sc_hd__and4_1
XFILLER_0_70_365 VGND VGND VPWR VPWR sky130_fd_sc_hd__fill_2
X_3585_ _0692_ _0693_ _0679_ VGND VGND VPWR VPWR _0695_ sky130_fd_sc_hd__a21oi_1
X_2536_ _1667_ _1660_ _1707_ _1716_ VGND VGND VPWR VPWR _1718_ sky130_fd_sc_hd__and4_2
X_2467_ _1653_ VGND VGND VPWR VPWR _0037_ sky130_fd_sc_hd__clkbuf_1
X_4206_ _1306_ _1310_ VGND VGND VPWR VPWR _1356_ sky130_fd_sc_hd__nand2_1
X_2398_ net50 _1596_ _1597_ VGND VGND VPWR VPWR _1598_ sky130_fd_sc_hd__mux2_1
X_4137_ _1253_ _1264_ VGND VGND VPWR VPWR _1281_ sky130_fd_sc_hd__nor2_1
XFILLER_0_3_51 VGND VGND VPWR VPWR sky130_fd_sc_hd__decap_4
X_4068_ _1205_ _1206_ VGND VGND VPWR VPWR _1207_ sky130_fd_sc_hd__and2b_1
XFILLER_0_64_81 VGND VGND VPWR VPWR sky130_fd_sc_hd__decap_3
X_3019_ _0095_ _0134_ _0135_ VGND VGND VPWR VPWR _0136_ sky130_fd_sc_hd__nor3_2
XFILLER_0_46_373 VGND VGND VPWR VPWR sky130_fd_sc_hd__decap_3
XFILLER_0_14_281 VGND VGND VPWR VPWR sky130_fd_sc_hd__decap_8
XFILLER_0_44_29 VPWR VGND VPWR VGND sky130_ef_sc_hd__decap_12
XFILLER_0_69_421 VPWR VGND VPWR VGND sky130_ef_sc_hd__decap_12
XFILLER_0_29_318 VPWR VGND VPWR VGND sky130_ef_sc_hd__decap_12
XFILLER_0_56_104 VPWR VGND VPWR VGND sky130_ef_sc_hd__decap_12
XFILLER_0_8_29 VGND VGND VPWR VPWR sky130_fd_sc_hd__fill_1
XFILLER_0_4_418 VGND VGND VPWR VPWR sky130_fd_sc_hd__fill_2
XFILLER_0_69_15 VPWR VGND VPWR VGND sky130_ef_sc_hd__decap_12
X_3370_ _0481_ _0482_ _0378_ _0386_ VGND VGND VPWR VPWR _0483_ sky130_fd_sc_hd__o211a_1
X_2321_ _1276_ _1533_ _1534_ VGND VGND VPWR VPWR _1535_ sky130_fd_sc_hd__o21a_1
X_2252_ add_tmp\[31\] net61 VGND VGND VPWR VPWR _1476_ sky130_fd_sc_hd__or2_1
X_2183_ _1404_ _1406_ VGND VGND VPWR VPWR _1407_ sky130_fd_sc_hd__or2b_1
XFILLER_0_28_340 VGND VGND VPWR VPWR sky130_fd_sc_hd__decap_3
XFILLER_0_43_310 VPWR VGND VPWR VGND sky130_ef_sc_hd__decap_12
XFILLER_0_50_83 VGND VGND VPWR VPWR sky130_fd_sc_hd__fill_1
X_3706_ _0812_ _0813_ _0730_ _0814_ VGND VGND VPWR VPWR _0815_ sky130_fd_sc_hd__o31a_1
XFILLER_0_43_376 VGND VGND VPWR VPWR sky130_fd_sc_hd__fill_1
X_3637_ _0520_ VGND VGND VPWR VPWR _0746_ sky130_fd_sc_hd__buf_2
XFILLER_0_70_173 VGND VGND VPWR VPWR sky130_fd_sc_hd__fill_2
XFILLER_0_70_195 VGND VGND VPWR VPWR sky130_fd_sc_hd__fill_1
XFILLER_0_11_251 VPWR VGND VPWR VGND sky130_ef_sc_hd__decap_12
X_3568_ _0620_ _0615_ _0614_ VGND VGND VPWR VPWR _0678_ sky130_fd_sc_hd__a21bo_1
X_2519_ _1698_ _1686_ _1701_ _1696_ VGND VGND VPWR VPWR _1702_ sky130_fd_sc_hd__and4b_1
X_3499_ _1939_ _0085_ _2035_ _1870_ VGND VGND VPWR VPWR _0610_ sky130_fd_sc_hd__a22o_1
XFILLER_0_66_457 VGND VGND VPWR VPWR sky130_fd_sc_hd__decap_6
XFILLER_0_53_107 VGND VGND VPWR VPWR sky130_fd_sc_hd__decap_4
XFILLER_0_46_192 VGND VGND VPWR VPWR sky130_fd_sc_hd__decap_4
XFILLER_0_34_365 VGND VGND VPWR VPWR sky130_fd_sc_hd__decap_4
XFILLER_0_34_398 VPWR VGND VPWR VGND sky130_ef_sc_hd__decap_12
XFILLER_0_55_17 VGND VGND VPWR VPWR sky130_fd_sc_hd__fill_1
XFILLER_0_69_262 VGND VGND VPWR VPWR sky130_fd_sc_hd__fill_1
X_2870_ _1969_ _1979_ _2044_ _2045_ VGND VGND VPWR VPWR _2046_ sky130_fd_sc_hd__a211oi_2
XFILLER_0_4_259 VGND VGND VPWR VPWR sky130_fd_sc_hd__decap_6
XFILLER_0_0_421 VPWR VGND VPWR VGND sky130_ef_sc_hd__decap_12
X_3422_ _0118_ VGND VGND VPWR VPWR _0534_ sky130_fd_sc_hd__clkbuf_2
XTAP_700 VGND VPWR sky130_fd_sc_hd__tapvpwrvgnd_1
X_3353_ _0464_ _0461_ _0463_ VGND VGND VPWR VPWR _0466_ sky130_fd_sc_hd__nand3_1
XTAP_711 VGND VPWR sky130_fd_sc_hd__tapvpwrvgnd_1
XTAP_722 VGND VPWR sky130_fd_sc_hd__tapvpwrvgnd_1
XTAP_733 VGND VPWR sky130_fd_sc_hd__tapvpwrvgnd_1
XTAP_777 VGND VPWR sky130_fd_sc_hd__tapvpwrvgnd_1
XTAP_766 VGND VPWR sky130_fd_sc_hd__tapvpwrvgnd_1
X_3284_ _0245_ VGND VGND VPWR VPWR _0398_ sky130_fd_sc_hd__clkbuf_2
X_2304_ _1520_ _1211_ VGND VGND VPWR VPWR _1521_ sky130_fd_sc_hd__xnor2_1
XTAP_744 VGND VPWR sky130_fd_sc_hd__tapvpwrvgnd_1
XTAP_755 VGND VPWR sky130_fd_sc_hd__tapvpwrvgnd_1
XTAP_788 VGND VPWR sky130_fd_sc_hd__tapvpwrvgnd_1
X_2235_ net60 add_tmp\[31\] VGND VGND VPWR VPWR _1459_ sky130_fd_sc_hd__nand2_1
X_2166_ net68 add_tmp\[6\] VGND VGND VPWR VPWR _1243_ sky130_fd_sc_hd__nand2_1
XFILLER_0_0_85 VGND VGND VPWR VPWR sky130_fd_sc_hd__decap_8
X_2999_ _1934_ _2016_ VGND VGND VPWR VPWR _0116_ sky130_fd_sc_hd__and2_4
XFILLER_0_63_449 VGND VGND VPWR VPWR sky130_fd_sc_hd__decap_4
XFILLER_0_16_365 VPWR VGND VPWR VGND sky130_ef_sc_hd__decap_12
XFILLER_0_43_151 VGND VGND VPWR VPWR sky130_fd_sc_hd__fill_1
XFILLER_0_9_83 VGND VGND VPWR VPWR sky130_fd_sc_hd__decap_6
XFILLER_0_3_281 VPWR VGND VPWR VGND sky130_ef_sc_hd__decap_12
XFILLER_0_66_221 VGND VGND VPWR VPWR sky130_fd_sc_hd__fill_2
XFILLER_0_66_276 VPWR VGND VPWR VGND sky130_ef_sc_hd__decap_12
XFILLER_0_66_38 VGND VGND VPWR VPWR sky130_fd_sc_hd__fill_1
X_3971_ _1100_ _1101_ VGND VGND VPWR VPWR _1102_ sky130_fd_sc_hd__and2_1
X_2922_ _1671_ _2092_ _2096_ _1657_ VGND VGND VPWR VPWR _2097_ sky130_fd_sc_hd__a22o_1
XFILLER_0_45_449 VGND VGND VPWR VPWR sky130_fd_sc_hd__decap_8
X_2853_ _2005_ _2027_ _2028_ VGND VGND VPWR VPWR _2029_ sky130_fd_sc_hd__and3_1
XFILLER_0_72_235 VGND VGND VPWR VPWR sky130_fd_sc_hd__fill_1
X_2784_ _1958_ _1960_ VGND VGND VPWR VPWR _1961_ sky130_fd_sc_hd__nor2_1
XFILLER_0_13_368 VPWR VGND VPWR VGND sky130_ef_sc_hd__decap_12
XFILLER_0_25_195 VGND VGND VPWR VPWR sky130_fd_sc_hd__fill_1
XFILLER_0_0_251 VGND VGND VPWR VPWR sky130_fd_sc_hd__fill_1
X_3405_ _0329_ VGND VGND VPWR VPWR _0517_ sky130_fd_sc_hd__buf_1
X_3336_ _1894_ VGND VGND VPWR VPWR _0449_ sky130_fd_sc_hd__buf_2
XTAP_530 VGND VPWR sky130_fd_sc_hd__tapvpwrvgnd_1
XTAP_541 VGND VPWR sky130_fd_sc_hd__tapvpwrvgnd_1
XTAP_552 VGND VPWR sky130_fd_sc_hd__tapvpwrvgnd_1
XTAP_563 VGND VPWR sky130_fd_sc_hd__tapvpwrvgnd_1
XTAP_574 VGND VPWR sky130_fd_sc_hd__tapvpwrvgnd_1
XTAP_585 VGND VPWR sky130_fd_sc_hd__tapvpwrvgnd_1
X_3267_ _1877_ _1927_ _0082_ VGND VGND VPWR VPWR _0381_ sky130_fd_sc_hd__and3_1
XTAP_596 VGND VPWR sky130_fd_sc_hd__tapvpwrvgnd_1
X_2218_ net55 add_tmp\[27\] VGND VGND VPWR VPWR _1442_ sky130_fd_sc_hd__or2_1
X_3198_ _0311_ _0312_ VGND VGND VPWR VPWR _0313_ sky130_fd_sc_hd__nand2_2
X_2149_ net68 add_tmp\[6\] VGND VGND VPWR VPWR _1059_ sky130_fd_sc_hd__nor2_1
XFILLER_0_36_405 VGND VGND VPWR VPWR sky130_fd_sc_hd__fill_2
XFILLER_0_48_298 VGND VGND VPWR VPWR sky130_fd_sc_hd__decap_6
XFILLER_0_63_246 VGND VGND VPWR VPWR sky130_fd_sc_hd__decap_6
XFILLER_0_16_184 VGND VGND VPWR VPWR sky130_fd_sc_hd__fill_2
XFILLER_0_31_110 VGND VGND VPWR VPWR sky130_fd_sc_hd__fill_2
XFILLER_0_16_195 VGND VGND VPWR VPWR sky130_fd_sc_hd__fill_1
XFILLER_0_31_154 VPWR VGND VPWR VGND sky130_ef_sc_hd__decap_12
XFILLER_0_31_187 VGND VGND VPWR VPWR sky130_fd_sc_hd__decap_6
XFILLER_0_52_29 VGND VGND VPWR VPWR sky130_fd_sc_hd__decap_6
XFILLER_0_39_254 VGND VGND VPWR VPWR sky130_fd_sc_hd__fill_2
XFILLER_0_39_265 VPWR VGND VPWR VGND sky130_ef_sc_hd__decap_12
XFILLER_0_27_449 VPWR VGND VPWR VGND sky130_ef_sc_hd__decap_12
XFILLER_0_54_235 VGND VGND VPWR VPWR sky130_fd_sc_hd__decap_3
XFILLER_0_42_419 VGND VGND VPWR VPWR sky130_fd_sc_hd__fill_1
XFILLER_0_54_279 VGND VGND VPWR VPWR sky130_fd_sc_hd__decap_6
XFILLER_0_22_154 VGND VGND VPWR VPWR sky130_fd_sc_hd__decap_6
XFILLER_0_22_187 VGND VGND VPWR VPWR sky130_fd_sc_hd__decap_8
X_4170_ _1256_ _1258_ _1259_ _1262_ VGND VGND VPWR VPWR _1317_ sky130_fd_sc_hd__o31ai_2
X_3121_ _0174_ _0179_ _0162_ VGND VGND VPWR VPWR _0236_ sky130_fd_sc_hd__o21ai_1
X_3052_ _1680_ _0164_ _0166_ _0167_ VGND VGND VPWR VPWR _0168_ sky130_fd_sc_hd__o2bb2a_1
XFILLER_0_26_85 VPWR VGND VPWR VGND sky130_ef_sc_hd__decap_12
X_3954_ _0934_ _0995_ VGND VGND VPWR VPWR _1084_ sky130_fd_sc_hd__nand2_1
XFILLER_0_45_202 VGND VGND VPWR VPWR sky130_fd_sc_hd__fill_2
XFILLER_0_18_438 VPWR VGND VPWR VGND sky130_ef_sc_hd__decap_12
X_3885_ _2036_ _0267_ _0326_ _0460_ VGND VGND VPWR VPWR _1009_ sky130_fd_sc_hd__a22o_1
XFILLER_0_42_95 VGND VGND VPWR VPWR sky130_fd_sc_hd__decap_3
X_2905_ _1877_ _1962_ _2076_ _2078_ VGND VGND VPWR VPWR _2080_ sky130_fd_sc_hd__nand4_1
X_2836_ _1783_ _1829_ _1830_ _2010_ VGND VGND VPWR VPWR _2012_ sky130_fd_sc_hd__a22o_1
XFILLER_0_60_216 VGND VGND VPWR VPWR sky130_fd_sc_hd__fill_2
XFILLER_0_13_121 VPWR VGND VPWR VGND sky130_ef_sc_hd__decap_12
X_2767_ _1935_ _1941_ _1943_ VGND VGND VPWR VPWR _1944_ sky130_fd_sc_hd__nand3_1
X_2698_ _1872_ _1873_ _1874_ VGND VGND VPWR VPWR _1876_ sky130_fd_sc_hd__a21o_1
XTAP_360 VGND VPWR sky130_fd_sc_hd__tapvpwrvgnd_1
XTAP_371 VGND VPWR sky130_fd_sc_hd__tapvpwrvgnd_1
XTAP_382 VGND VPWR sky130_fd_sc_hd__tapvpwrvgnd_1
XTAP_393 VGND VPWR sky130_fd_sc_hd__tapvpwrvgnd_1
X_3319_ _1956_ _0431_ VGND VGND VPWR VPWR _0432_ sky130_fd_sc_hd__nand2_1
X_4299_ clknet_3_3__leaf_clk _0044_ net35 VGND VGND VPWR VPWR add_tmp\[6\] sky130_fd_sc_hd__dfrtp_1
XPHY_22 VGND VGND VPWR VPWR sky130_fd_sc_hd__decap_3
XPHY_11 VGND VGND VPWR VPWR sky130_fd_sc_hd__decap_3
Xrebuffer62 _2059_ VGND VGND VPWR VPWR net148 sky130_fd_sc_hd__dlygate4sd1_1
Xrebuffer40 _2003_ VGND VGND VPWR VPWR net113 sky130_fd_sc_hd__clkbuf_1
Xrebuffer51 _0288_ VGND VGND VPWR VPWR net124 sky130_fd_sc_hd__clkbuf_1
XPHY_33 VGND VGND VPWR VPWR sky130_fd_sc_hd__decap_3
XPHY_44 VGND VGND VPWR VPWR sky130_fd_sc_hd__decap_3
XPHY_55 VGND VGND VPWR VPWR sky130_fd_sc_hd__decap_3
XPHY_66 VGND VGND VPWR VPWR sky130_fd_sc_hd__decap_3
XPHY_77 VGND VGND VPWR VPWR sky130_fd_sc_hd__decap_3
XPHY_88 VGND VGND VPWR VPWR sky130_fd_sc_hd__decap_3
XPHY_99 VGND VGND VPWR VPWR sky130_fd_sc_hd__decap_3
XFILLER_0_63_39 VPWR VGND VPWR VGND sky130_ef_sc_hd__decap_12
XFILLER_0_67_382 VGND VGND VPWR VPWR sky130_fd_sc_hd__decap_8
XFILLER_0_67_393 VPWR VGND VPWR VGND sky130_ef_sc_hd__decap_12
XFILLER_0_27_279 VGND VGND VPWR VPWR sky130_fd_sc_hd__fill_1
X_3670_ _0708_ VGND VGND VPWR VPWR _0779_ sky130_fd_sc_hd__clkbuf_2
X_2621_ net126 _1758_ _1796_ _1800_ VGND VGND VPWR VPWR _1801_ sky130_fd_sc_hd__o211a_1
XFILLER_0_42_238 VPWR VGND VPWR VGND sky130_ef_sc_hd__decap_12
XFILLER_0_2_324 VGND VGND VPWR VPWR sky130_fd_sc_hd__decap_4
X_2552_ _1698_ _1702_ _1732_ _1733_ VGND VGND VPWR VPWR _1734_ sky130_fd_sc_hd__o211a_1
X_4222_ _1282_ _1339_ _1303_ VGND VGND VPWR VPWR _1373_ sky130_fd_sc_hd__o21bai_1
X_2483_ _1667_ VGND VGND VPWR VPWR _1668_ sky130_fd_sc_hd__dlymetal6s2s_1
XFILLER_0_10_179 VGND VGND VPWR VPWR sky130_fd_sc_hd__fill_2
X_4153_ _1282_ _1298_ VGND VGND VPWR VPWR _1299_ sky130_fd_sc_hd__and2_1
X_4084_ _1221_ _1224_ VGND VGND VPWR VPWR _1225_ sky130_fd_sc_hd__xnor2_1
X_3104_ _0178_ _0179_ _0218_ _0219_ VGND VGND VPWR VPWR _0220_ sky130_fd_sc_hd__o22a_2
X_3035_ _2109_ _0096_ net108 _0133_ VGND VGND VPWR VPWR _0151_ sky130_fd_sc_hd__a211o_1
XFILLER_0_77_135 VGND VGND VPWR VPWR sky130_fd_sc_hd__decap_4
XFILLER_0_53_50 VGND VGND VPWR VPWR sky130_fd_sc_hd__decap_6
XFILLER_0_18_235 VPWR VGND VPWR VGND sky130_ef_sc_hd__decap_12
X_3937_ _1062_ _1064_ VGND VGND VPWR VPWR _1065_ sky130_fd_sc_hd__nand2_1
X_3868_ _0969_ _0958_ _0959_ VGND VGND VPWR VPWR _0990_ sky130_fd_sc_hd__nor3_1
XFILLER_0_33_205 VGND VGND VPWR VPWR sky130_fd_sc_hd__fill_1
X_3799_ _0369_ _0462_ _0433_ _0857_ VGND VGND VPWR VPWR _0915_ sky130_fd_sc_hd__nand4_4
XFILLER_0_33_238 VGND VGND VPWR VPWR sky130_fd_sc_hd__decap_6
X_2819_ _1960_ _1963_ _1958_ VGND VGND VPWR VPWR _1995_ sky130_fd_sc_hd__o21ba_1
XFILLER_0_5_184 VPWR VGND VPWR VGND sky130_ef_sc_hd__decap_12
XFILLER_0_41_293 VGND VGND VPWR VPWR sky130_fd_sc_hd__decap_3
XTAP_190 VGND VPWR sky130_fd_sc_hd__tapvpwrvgnd_1
XFILLER_0_49_393 VPWR VGND VPWR VGND sky130_ef_sc_hd__decap_12
XFILLER_0_76_190 VGND VGND VPWR VPWR sky130_fd_sc_hd__decap_6
Xinput18 in_a[9] VGND VGND VPWR VPWR net18 sky130_fd_sc_hd__buf_6
XFILLER_0_64_363 VGND VGND VPWR VPWR sky130_fd_sc_hd__fill_1
Xinput29 in_b[4] VGND VGND VPWR VPWR net29 sky130_fd_sc_hd__buf_8
XFILLER_0_32_271 VPWR VGND VPWR VGND sky130_ef_sc_hd__decap_12
XFILLER_0_74_27 VGND VGND VPWR VPWR sky130_fd_sc_hd__fill_1
XFILLER_0_59_113 VGND VGND VPWR VPWR sky130_fd_sc_hd__decap_4
XFILLER_0_59_124 VGND VGND VPWR VPWR sky130_fd_sc_hd__fill_1
XFILLER_0_47_308 VPWR VGND VPWR VGND sky130_ef_sc_hd__decap_12
XFILLER_0_7_449 VGND VGND VPWR VPWR sky130_fd_sc_hd__decap_8
XFILLER_0_7_416 VPWR VGND VPWR VGND sky130_ef_sc_hd__decap_12
XFILLER_0_55_330 VGND VGND VPWR VPWR sky130_fd_sc_hd__decap_6
X_3722_ _0775_ _0776_ _0800_ VGND VGND VPWR VPWR _0832_ sky130_fd_sc_hd__or3_4
XFILLER_0_15_249 VPWR VGND VPWR VGND sky130_ef_sc_hd__decap_12
X_3653_ _0761_ _0376_ _0758_ _0759_ VGND VGND VPWR VPWR _0762_ sky130_fd_sc_hd__a22o_1
XFILLER_0_2_110 VGND VGND VPWR VPWR sky130_fd_sc_hd__decap_3
X_2604_ _1697_ _1782_ _1783_ _1752_ VGND VGND VPWR VPWR _1784_ sky130_fd_sc_hd__a22oi_2
XFILLER_0_70_388 VGND VGND VPWR VPWR sky130_fd_sc_hd__fill_1
X_3584_ _0679_ _0692_ _0693_ VGND VGND VPWR VPWR _0694_ sky130_fd_sc_hd__and3_1
XFILLER_0_2_187 VGND VGND VPWR VPWR sky130_fd_sc_hd__fill_1
X_2535_ _1667_ _1707_ _1716_ _1661_ VGND VGND VPWR VPWR _1717_ sky130_fd_sc_hd__a22oi_1
X_2466_ net64 _1652_ _1636_ VGND VGND VPWR VPWR _1653_ sky130_fd_sc_hd__mux2_1
XFILLER_0_48_50 VPWR VGND VPWR VGND sky130_ef_sc_hd__decap_12
X_4205_ _1352_ _1354_ VGND VGND VPWR VPWR _1355_ sky130_fd_sc_hd__xnor2_1
X_2397_ _1492_ VGND VGND VPWR VPWR _1597_ sky130_fd_sc_hd__clkbuf_4
X_4136_ _1251_ _1252_ VGND VGND VPWR VPWR _1280_ sky130_fd_sc_hd__and2_1
X_4067_ _1183_ _1185_ _1204_ VGND VGND VPWR VPWR _1206_ sky130_fd_sc_hd__o21ai_1
XFILLER_0_3_96 VPWR VGND VPWR VGND sky130_ef_sc_hd__decap_12
X_3018_ _0132_ _0133_ _2109_ _0096_ VGND VGND VPWR VPWR _0135_ sky130_fd_sc_hd__o211a_1
XFILLER_0_64_93 VGND VGND VPWR VPWR sky130_fd_sc_hd__fill_2
XFILLER_0_38_319 VGND VGND VPWR VPWR sky130_fd_sc_hd__decap_6
XFILLER_0_65_149 VGND VGND VPWR VPWR sky130_fd_sc_hd__fill_1
XFILLER_0_69_433 VPWR VGND VPWR VGND sky130_ef_sc_hd__decap_12
XFILLER_0_56_116 VPWR VGND VPWR VGND sky130_ef_sc_hd__decap_12
XFILLER_0_60_29 VGND VGND VPWR VPWR sky130_fd_sc_hd__fill_2
XFILLER_0_52_322 VGND VGND VPWR VPWR sky130_fd_sc_hd__decap_4
XFILLER_0_69_27 VGND VGND VPWR VPWR sky130_fd_sc_hd__decap_6
X_2320_ _1276_ _1533_ _1485_ VGND VGND VPWR VPWR _1534_ sky130_fd_sc_hd__a21oi_1
X_2251_ _0821_ net61 VGND VGND VPWR VPWR _1475_ sky130_fd_sc_hd__nand2_1
XFILLER_0_18_20 VGND VGND VPWR VPWR sky130_fd_sc_hd__decap_8
X_2182_ net44 add_tmp\[17\] VGND VGND VPWR VPWR _1406_ sky130_fd_sc_hd__nand2_1
XFILLER_0_34_85 VPWR VGND VPWR VGND sky130_ef_sc_hd__decap_12
XFILLER_0_7_202 VGND VGND VPWR VPWR sky130_fd_sc_hd__decap_8
XFILLER_0_7_257 VGND VGND VPWR VPWR sky130_fd_sc_hd__fill_2
XFILLER_0_28_374 VPWR VGND VPWR VGND sky130_ef_sc_hd__decap_12
XFILLER_0_7_268 VPWR VGND VPWR VGND sky130_ef_sc_hd__decap_12
XFILLER_0_43_322 VGND VGND VPWR VPWR sky130_fd_sc_hd__decap_6
X_3705_ _0670_ _0731_ VGND VGND VPWR VPWR _0814_ sky130_fd_sc_hd__nand2_1
XFILLER_0_70_141 VGND VGND VPWR VPWR sky130_fd_sc_hd__fill_2
XFILLER_0_3_441 VGND VGND VPWR VPWR sky130_fd_sc_hd__decap_6
X_3636_ _0289_ _0744_ _0688_ VGND VGND VPWR VPWR _0745_ sky130_fd_sc_hd__and3b_2
X_3567_ _0600_ _0676_ VGND VGND VPWR VPWR _0677_ sky130_fd_sc_hd__xor2_2
XFILLER_0_11_263 VPWR VGND VPWR VGND sky130_ef_sc_hd__decap_12
X_2518_ _1666_ VGND VGND VPWR VPWR _1701_ sky130_fd_sc_hd__buf_1
X_3498_ _0545_ _0552_ _0551_ VGND VGND VPWR VPWR _0609_ sky130_fd_sc_hd__a21oi_1
X_2449_ _1470_ _1473_ _1477_ VGND VGND VPWR VPWR _1639_ sky130_fd_sc_hd__a21o_1
XFILLER_0_75_81 VPWR VGND VPWR VGND sky130_ef_sc_hd__decap_12
X_4119_ _1255_ _1261_ VGND VGND VPWR VPWR _1262_ sky130_fd_sc_hd__nand2_1
XFILLER_0_34_300 VGND VGND VPWR VPWR sky130_fd_sc_hd__fill_1
XFILLER_0_34_355 VGND VGND VPWR VPWR sky130_fd_sc_hd__decap_8
XFILLER_0_61_130 VPWR VGND VPWR VGND sky130_ef_sc_hd__decap_12
XFILLER_0_61_163 VGND VGND VPWR VPWR sky130_fd_sc_hd__fill_1
XFILLER_0_25_311 VGND VGND VPWR VPWR sky130_fd_sc_hd__fill_2
XFILLER_0_52_141 VPWR VGND VPWR VGND sky130_ef_sc_hd__decap_12
XFILLER_0_52_174 VPWR VGND VPWR VGND sky130_ef_sc_hd__decap_12
X_3421_ _0531_ _0532_ _0422_ _0424_ VGND VGND VPWR VPWR _0533_ sky130_fd_sc_hd__o211ai_4
XFILLER_0_40_358 VGND VGND VPWR VPWR sky130_fd_sc_hd__decap_6
XFILLER_0_0_433 VPWR VGND VPWR VGND sky130_ef_sc_hd__decap_12
X_3352_ _0461_ _0463_ _0464_ VGND VGND VPWR VPWR _0465_ sky130_fd_sc_hd__a21o_1
XTAP_701 VGND VPWR sky130_fd_sc_hd__tapvpwrvgnd_1
X_2303_ _1222_ _1070_ VGND VGND VPWR VPWR _1520_ sky130_fd_sc_hd__nand2_1
XTAP_712 VGND VPWR sky130_fd_sc_hd__tapvpwrvgnd_1
XTAP_723 VGND VPWR sky130_fd_sc_hd__tapvpwrvgnd_1
XTAP_734 VGND VPWR sky130_fd_sc_hd__tapvpwrvgnd_1
XTAP_767 VGND VPWR sky130_fd_sc_hd__tapvpwrvgnd_1
X_3283_ _0394_ _0395_ net93 _0306_ VGND VGND VPWR VPWR _0397_ sky130_fd_sc_hd__o211ai_1
XTAP_745 VGND VPWR sky130_fd_sc_hd__tapvpwrvgnd_1
XTAP_756 VGND VPWR sky130_fd_sc_hd__tapvpwrvgnd_1
XTAP_789 VGND VPWR sky130_fd_sc_hd__tapvpwrvgnd_1
XTAP_778 VGND VPWR sky130_fd_sc_hd__tapvpwrvgnd_1
X_2234_ _1456_ _1457_ VGND VGND VPWR VPWR _1458_ sky130_fd_sc_hd__or2b_1
X_2165_ _1070_ _1211_ _1222_ VGND VGND VPWR VPWR _1232_ sky130_fd_sc_hd__a21boi_1
XFILLER_0_48_414 VGND VGND VPWR VPWR sky130_fd_sc_hd__decap_6
XFILLER_0_48_447 VPWR VGND VPWR VGND sky130_ef_sc_hd__decap_12
XFILLER_0_61_61 VGND VGND VPWR VPWR sky130_fd_sc_hd__decap_8
XFILLER_0_63_417 VGND VGND VPWR VPWR sky130_fd_sc_hd__fill_1
XFILLER_0_28_171 VGND VGND VPWR VPWR sky130_fd_sc_hd__decap_4
X_2998_ _0109_ _0114_ VGND VGND VPWR VPWR _0115_ sky130_fd_sc_hd__xnor2_2
XFILLER_0_71_461 VGND VGND VPWR VPWR sky130_fd_sc_hd__fill_2
XFILLER_0_9_73 VGND VGND VPWR VPWR sky130_fd_sc_hd__fill_2
XFILLER_0_43_196 VGND VGND VPWR VPWR sky130_fd_sc_hd__fill_2
X_3619_ _0655_ _0656_ VGND VGND VPWR VPWR _0729_ sky130_fd_sc_hd__nand2_1
XFILLER_0_3_293 VPWR VGND VPWR VGND sky130_ef_sc_hd__decap_12
XFILLER_0_39_447 VGND VGND VPWR VPWR sky130_fd_sc_hd__fill_1
XFILLER_0_66_266 VGND VGND VPWR VPWR sky130_fd_sc_hd__decap_6
XFILLER_0_66_288 VPWR VGND VPWR VGND sky130_ef_sc_hd__decap_12
XFILLER_0_15_21 VGND VGND VPWR VPWR sky130_fd_sc_hd__decap_8
XFILLER_0_15_65 VPWR VGND VPWR VGND sky130_ef_sc_hd__decap_12
X_3970_ _1024_ _1028_ _1099_ VGND VGND VPWR VPWR _1101_ sky130_fd_sc_hd__o21ai_2
X_2921_ net5 VGND VGND VPWR VPWR _2096_ sky130_fd_sc_hd__buf_4
X_2852_ _2024_ _2025_ _2026_ VGND VGND VPWR VPWR _2028_ sky130_fd_sc_hd__a21o_1
X_2783_ _1842_ _1959_ _1817_ _1896_ VGND VGND VPWR VPWR _1960_ sky130_fd_sc_hd__a22oi_2
XFILLER_0_53_461 VGND VGND VPWR VPWR sky130_fd_sc_hd__fill_2
XFILLER_0_25_174 VGND VGND VPWR VPWR sky130_fd_sc_hd__fill_1
X_3404_ _0492_ _0493_ VGND VGND VPWR VPWR _0516_ sky130_fd_sc_hd__and2_1
XFILLER_0_40_166 VGND VGND VPWR VPWR sky130_fd_sc_hd__decap_8
XFILLER_0_21_391 VGND VGND VPWR VPWR sky130_fd_sc_hd__fill_1
XTAP_520 VGND VPWR sky130_fd_sc_hd__tapvpwrvgnd_1
XTAP_531 VGND VPWR sky130_fd_sc_hd__tapvpwrvgnd_1
XTAP_542 VGND VPWR sky130_fd_sc_hd__tapvpwrvgnd_1
X_3335_ _0191_ _0208_ _0446_ _0447_ VGND VGND VPWR VPWR _0448_ sky130_fd_sc_hd__a22o_1
X_3266_ _1680_ _0159_ VGND VGND VPWR VPWR _0380_ sky130_fd_sc_hd__nand2_2
XTAP_553 VGND VPWR sky130_fd_sc_hd__tapvpwrvgnd_1
XTAP_564 VGND VPWR sky130_fd_sc_hd__tapvpwrvgnd_1
XTAP_575 VGND VPWR sky130_fd_sc_hd__tapvpwrvgnd_1
X_2217_ net55 add_tmp\[27\] VGND VGND VPWR VPWR _1441_ sky130_fd_sc_hd__nand2_1
XTAP_586 VGND VPWR sky130_fd_sc_hd__tapvpwrvgnd_1
XTAP_597 VGND VPWR sky130_fd_sc_hd__tapvpwrvgnd_1
XFILLER_0_56_61 VGND VGND VPWR VPWR sky130_fd_sc_hd__decap_8
XFILLER_0_22_3 VGND VGND VPWR VPWR sky130_fd_sc_hd__decap_8
X_3197_ _0309_ _0310_ _0227_ _0235_ VGND VGND VPWR VPWR _0312_ sky130_fd_sc_hd__a211o_1
X_2148_ net69 add_tmp\[7\] VGND VGND VPWR VPWR _1049_ sky130_fd_sc_hd__nor2_1
XFILLER_0_8_363 VGND VGND VPWR VPWR sky130_fd_sc_hd__fill_1
XFILLER_0_63_214 VGND VGND VPWR VPWR sky130_fd_sc_hd__fill_2
XFILLER_0_63_225 VGND VGND VPWR VPWR sky130_fd_sc_hd__decap_4
XFILLER_0_16_152 VGND VGND VPWR VPWR sky130_fd_sc_hd__decap_3
XFILLER_0_31_166 VGND VGND VPWR VPWR sky130_fd_sc_hd__fill_2
XFILLER_0_12_391 VPWR VGND VPWR VGND sky130_ef_sc_hd__decap_12
XFILLER_0_39_277 VGND VGND VPWR VPWR sky130_fd_sc_hd__decap_3
XFILLER_0_22_122 VPWR VGND VPWR VGND sky130_ef_sc_hd__decap_12
XFILLER_0_50_442 VGND VGND VPWR VPWR sky130_fd_sc_hd__decap_8
XFILLER_0_77_27 VGND VGND VPWR VPWR sky130_fd_sc_hd__fill_1
X_3120_ _0225_ _0222_ _0223_ VGND VGND VPWR VPWR _0235_ sky130_fd_sc_hd__and3b_1
X_3051_ _1697_ _1840_ _0085_ _2035_ VGND VGND VPWR VPWR _0167_ sky130_fd_sc_hd__and4_1
XFILLER_0_26_64 VGND VGND VPWR VPWR sky130_fd_sc_hd__fill_1
XFILLER_0_26_97 VPWR VGND VPWR VGND sky130_ef_sc_hd__decap_12
XFILLER_0_18_406 VGND VGND VPWR VPWR sky130_fd_sc_hd__fill_1
XFILLER_0_9_149 VPWR VGND VPWR VGND sky130_ef_sc_hd__decap_12
XFILLER_0_9_127 VGND VGND VPWR VPWR sky130_fd_sc_hd__decap_6
X_3953_ _0952_ _1003_ VGND VGND VPWR VPWR _1083_ sky130_fd_sc_hd__nand2_1
X_3884_ _0943_ _0947_ VGND VGND VPWR VPWR _1008_ sky130_fd_sc_hd__nand2_1
XFILLER_0_45_225 VGND VGND VPWR VPWR sky130_fd_sc_hd__decap_8
X_2904_ _1877_ _1903_ _2076_ _2078_ VGND VGND VPWR VPWR _2079_ sky130_fd_sc_hd__a22o_1
XFILLER_0_26_450 VGND VGND VPWR VPWR sky130_fd_sc_hd__decap_6
X_2835_ _2010_ _1755_ _1774_ _1827_ VGND VGND VPWR VPWR _2011_ sky130_fd_sc_hd__and4_1
XFILLER_0_13_133 VGND VGND VPWR VPWR sky130_fd_sc_hd__decap_3
X_2766_ _1693_ _1867_ _1942_ _1695_ VGND VGND VPWR VPWR _1943_ sky130_fd_sc_hd__a22o_4
XFILLER_0_60_239 VPWR VGND VPWR VGND sky130_ef_sc_hd__decap_12
X_2697_ _1872_ _1873_ _1874_ VGND VGND VPWR VPWR _1875_ sky130_fd_sc_hd__nand3_1
XFILLER_0_13_199 VPWR VGND VPWR VGND sky130_ef_sc_hd__decap_12
XFILLER_0_6_85 VGND VGND VPWR VPWR sky130_fd_sc_hd__decap_6
XTAP_350 VGND VPWR sky130_fd_sc_hd__tapvpwrvgnd_1
X_3318_ _0430_ VGND VGND VPWR VPWR _0431_ sky130_fd_sc_hd__clkbuf_2
XTAP_361 VGND VPWR sky130_fd_sc_hd__tapvpwrvgnd_1
XTAP_372 VGND VPWR sky130_fd_sc_hd__tapvpwrvgnd_1
XTAP_383 VGND VPWR sky130_fd_sc_hd__tapvpwrvgnd_1
XTAP_394 VGND VPWR sky130_fd_sc_hd__tapvpwrvgnd_1
X_4298_ clknet_3_3__leaf_clk _0043_ net35 VGND VGND VPWR VPWR add_tmp\[5\] sky130_fd_sc_hd__dfrtp_1
X_3249_ _0350_ _0351_ _0362_ VGND VGND VPWR VPWR _0363_ sky130_fd_sc_hd__a21oi_2
Xrebuffer30 _2046_ VGND VGND VPWR VPWR net103 sky130_fd_sc_hd__clkbuf_1
XPHY_12 VGND VGND VPWR VPWR sky130_fd_sc_hd__decap_3
Xrebuffer63 _1724_ VGND VGND VPWR VPWR net149 sky130_fd_sc_hd__dlymetal6s2s_1
Xrebuffer41 _0167_ VGND VGND VPWR VPWR net114 sky130_fd_sc_hd__clkbuf_1
Xrebuffer52 _0297_ VGND VGND VPWR VPWR net125 sky130_fd_sc_hd__clkbuf_1
XPHY_34 VGND VGND VPWR VPWR sky130_fd_sc_hd__decap_3
XPHY_23 VGND VGND VPWR VPWR sky130_fd_sc_hd__decap_3
XPHY_45 VGND VGND VPWR VPWR sky130_fd_sc_hd__decap_3
XPHY_56 VGND VGND VPWR VPWR sky130_fd_sc_hd__decap_3
XPHY_67 VGND VGND VPWR VPWR sky130_fd_sc_hd__decap_3
XPHY_78 VGND VGND VPWR VPWR sky130_fd_sc_hd__decap_3
XPHY_89 VGND VGND VPWR VPWR sky130_fd_sc_hd__decap_3
XFILLER_0_36_247 VGND VGND VPWR VPWR sky130_fd_sc_hd__decap_4
XFILLER_0_44_291 VGND VGND VPWR VPWR sky130_fd_sc_hd__fill_2
XFILLER_0_67_361 VPWR VGND VPWR VGND sky130_ef_sc_hd__decap_12
XFILLER_0_6_108 VGND VGND VPWR VPWR sky130_fd_sc_hd__fill_1
X_2620_ _1799_ VGND VGND VPWR VPWR _1800_ sky130_fd_sc_hd__clkbuf_2
XFILLER_0_42_217 VPWR VGND VPWR VGND sky130_ef_sc_hd__decap_12
XFILLER_0_23_420 VPWR VGND VPWR VGND sky130_ef_sc_hd__decap_12
XFILLER_0_35_291 VGND VGND VPWR VPWR sky130_fd_sc_hd__decap_4
X_2551_ _1731_ net149 _1728_ VGND VGND VPWR VPWR _1733_ sky130_fd_sc_hd__nand3_1
XFILLER_0_10_114 VGND VGND VPWR VPWR sky130_fd_sc_hd__fill_1
X_2482_ _1666_ VGND VGND VPWR VPWR _1667_ sky130_fd_sc_hd__buf_1
X_4221_ _1346_ _1370_ VGND VGND VPWR VPWR _1371_ sky130_fd_sc_hd__xnor2_1
X_4152_ _1284_ _1296_ VGND VGND VPWR VPWR _1298_ sky130_fd_sc_hd__xnor2_1
X_4083_ _1096_ _1163_ _1223_ VGND VGND VPWR VPWR _1224_ sky130_fd_sc_hd__a21bo_1
X_3103_ _0216_ _0217_ _0130_ _0180_ VGND VGND VPWR VPWR _0219_ sky130_fd_sc_hd__o211a_1
X_3034_ _0074_ _0147_ _0145_ VGND VGND VPWR VPWR _0150_ sky130_fd_sc_hd__o21ba_1
XFILLER_0_77_169 VPWR VGND VPWR VGND sky130_ef_sc_hd__decap_12
XFILLER_0_58_361 VGND VGND VPWR VPWR sky130_fd_sc_hd__decap_3
X_3936_ _1063_ VGND VGND VPWR VPWR _1064_ sky130_fd_sc_hd__inv_2
XFILLER_0_18_247 VGND VGND VPWR VPWR sky130_fd_sc_hd__fill_2
X_3867_ _0888_ _0968_ VGND VGND VPWR VPWR _0989_ sky130_fd_sc_hd__nand2_1
X_3798_ _0371_ _0433_ _0267_ _0249_ VGND VGND VPWR VPWR _0914_ sky130_fd_sc_hd__a22o_1
XFILLER_0_26_280 VGND VGND VPWR VPWR sky130_fd_sc_hd__decap_8
X_2818_ _1664_ _1975_ _1972_ VGND VGND VPWR VPWR _1994_ sky130_fd_sc_hd__and3_2
XFILLER_0_5_196 VGND VGND VPWR VPWR sky130_fd_sc_hd__decap_6
X_2749_ _1926_ VGND VGND VPWR VPWR _0046_ sky130_fd_sc_hd__clkbuf_1
XTAP_180 VGND VPWR sky130_fd_sc_hd__tapvpwrvgnd_1
XTAP_191 VGND VPWR sky130_fd_sc_hd__tapvpwrvgnd_1
XFILLER_0_68_136 VGND VGND VPWR VPWR sky130_fd_sc_hd__decap_4
XFILLER_0_49_361 VPWR VGND VPWR VGND sky130_ef_sc_hd__decap_12
Xinput19 in_b[0] VGND VGND VPWR VPWR net19 sky130_fd_sc_hd__buf_6
XFILLER_0_24_217 VPWR VGND VPWR VGND sky130_ef_sc_hd__decap_12
XFILLER_0_32_283 VPWR VGND VPWR VGND sky130_ef_sc_hd__decap_12
XFILLER_0_58_29 VPWR VGND VPWR VGND sky130_ef_sc_hd__decap_12
XFILLER_0_59_169 VGND VGND VPWR VPWR sky130_fd_sc_hd__decap_8
XFILLER_0_74_117 VGND VGND VPWR VPWR sky130_fd_sc_hd__fill_1
XFILLER_0_74_139 VGND VGND VPWR VPWR sky130_fd_sc_hd__fill_1
XFILLER_0_7_428 VPWR VGND VPWR VGND sky130_ef_sc_hd__decap_12
XFILLER_0_55_320 VGND VGND VPWR VPWR sky130_fd_sc_hd__fill_2
XFILLER_0_55_375 VGND VGND VPWR VPWR sky130_fd_sc_hd__decap_4
X_3721_ _0829_ VGND VGND VPWR VPWR _0830_ sky130_fd_sc_hd__inv_2
X_3652_ _0757_ VGND VGND VPWR VPWR _0761_ sky130_fd_sc_hd__dlymetal6s2s_1
X_2603_ _1754_ VGND VGND VPWR VPWR _1783_ sky130_fd_sc_hd__buf_6
X_3583_ _0691_ _0685_ _0686_ VGND VGND VPWR VPWR _0693_ sky130_fd_sc_hd__nand3_1
X_2534_ _1715_ VGND VGND VPWR VPWR _1716_ sky130_fd_sc_hd__clkbuf_2
X_2465_ _1488_ _1650_ _1651_ _1634_ VGND VGND VPWR VPWR _1652_ sky130_fd_sc_hd__o31ai_1
X_2396_ _1595_ add_tmp\[22\] _1577_ VGND VGND VPWR VPWR _1596_ sky130_fd_sc_hd__mux2_1
X_4204_ _1353_ _1312_ _1304_ VGND VGND VPWR VPWR _1354_ sky130_fd_sc_hd__o21ai_1
XFILLER_0_48_62 VPWR VGND VPWR VGND sky130_ef_sc_hd__decap_12
X_4135_ _1268_ _1269_ VGND VGND VPWR VPWR _1279_ sky130_fd_sc_hd__or2b_1
X_4066_ _1183_ _1185_ _1204_ VGND VGND VPWR VPWR _1205_ sky130_fd_sc_hd__nor3_1
XFILLER_0_64_61 VPWR VGND VPWR VGND sky130_ef_sc_hd__decap_12
X_3017_ _2109_ _0096_ _0132_ _0133_ VGND VGND VPWR VPWR _0134_ sky130_fd_sc_hd__a211oi_2
XFILLER_0_38_309 VGND VGND VPWR VPWR sky130_fd_sc_hd__fill_2
XFILLER_0_58_191 VGND VGND VPWR VPWR sky130_fd_sc_hd__decap_4
X_3919_ _1043_ _1044_ _0967_ _0989_ VGND VGND VPWR VPWR _1046_ sky130_fd_sc_hd__o211a_1
XFILLER_0_69_445 VGND VGND VPWR VPWR sky130_fd_sc_hd__decap_3
XFILLER_0_56_128 VPWR VGND VPWR VGND sky130_ef_sc_hd__decap_12
XFILLER_0_52_334 VGND VGND VPWR VPWR sky130_fd_sc_hd__decap_3
XFILLER_0_69_39 VPWR VGND VPWR VGND sky130_ef_sc_hd__decap_12
XFILLER_0_20_253 VGND VGND VPWR VPWR sky130_fd_sc_hd__decap_8
X_2250_ _0821_ net62 VGND VGND VPWR VPWR _1474_ sky130_fd_sc_hd__xnor2_1
X_2181_ net44 add_tmp\[17\] VGND VGND VPWR VPWR _1404_ sky130_fd_sc_hd__nor2_1
XFILLER_0_34_42 VPWR VGND VPWR VGND sky130_ef_sc_hd__decap_12
XFILLER_0_34_97 VGND VGND VPWR VPWR sky130_fd_sc_hd__decap_8
XFILLER_0_47_106 VGND VGND VPWR VPWR sky130_fd_sc_hd__fill_1
XFILLER_0_7_225 VPWR VGND VPWR VGND sky130_ef_sc_hd__decap_12
XFILLER_0_28_386 VGND VGND VPWR VPWR sky130_fd_sc_hd__decap_8
XFILLER_0_50_85 VPWR VGND VPWR VGND sky130_ef_sc_hd__decap_12
X_3704_ _0677_ _0726_ VGND VGND VPWR VPWR _0813_ sky130_fd_sc_hd__and2_1
XFILLER_0_43_345 VGND VGND VPWR VPWR sky130_fd_sc_hd__fill_1
X_3635_ _0329_ VGND VGND VPWR VPWR _0744_ sky130_fd_sc_hd__buf_2
X_3566_ _0671_ _0675_ VGND VGND VPWR VPWR _0676_ sky130_fd_sc_hd__xor2_2
XFILLER_0_11_275 VGND VGND VPWR VPWR sky130_fd_sc_hd__fill_1
X_2517_ _1669_ _1687_ _1696_ _1699_ VGND VGND VPWR VPWR _1700_ sky130_fd_sc_hd__a22oi_1
X_3497_ _0567_ _0576_ VGND VGND VPWR VPWR _0608_ sky130_fd_sc_hd__nand2_1
X_2448_ _1477_ _1470_ _1473_ VGND VGND VPWR VPWR _1638_ sky130_fd_sc_hd__and3_1
X_2379_ _1413_ _1575_ _1411_ VGND VGND VPWR VPWR _1582_ sky130_fd_sc_hd__o21ai_1
XFILLER_0_75_93 VGND VGND VPWR VPWR sky130_fd_sc_hd__decap_6
X_4118_ _1256_ _1260_ VGND VGND VPWR VPWR _1261_ sky130_fd_sc_hd__xnor2_1
X_4049_ _1138_ _1148_ _1147_ VGND VGND VPWR VPWR _1186_ sky130_fd_sc_hd__a21o_1
XFILLER_0_34_323 VGND VGND VPWR VPWR sky130_fd_sc_hd__decap_6
XFILLER_0_34_334 VGND VGND VPWR VPWR sky130_fd_sc_hd__decap_6
XFILLER_0_46_172 VGND VGND VPWR VPWR sky130_fd_sc_hd__decap_3
XFILLER_0_61_142 VGND VGND VPWR VPWR sky130_fd_sc_hd__decap_6
XFILLER_0_57_404 VPWR VGND VPWR VGND sky130_ef_sc_hd__decap_12
XFILLER_0_72_407 VGND VGND VPWR VPWR sky130_fd_sc_hd__decap_4
XFILLER_0_52_153 VGND VGND VPWR VPWR sky130_fd_sc_hd__decap_3
XFILLER_0_20_44 VGND VGND VPWR VPWR sky130_fd_sc_hd__fill_1
XFILLER_0_52_164 VGND VGND VPWR VPWR sky130_fd_sc_hd__decap_4
X_3420_ _1686_ _0422_ _0423_ VGND VGND VPWR VPWR _0532_ sky130_fd_sc_hd__and3_1
XFILLER_0_52_197 VGND VGND VPWR VPWR sky130_fd_sc_hd__fill_1
XFILLER_0_0_445 VGND VGND VPWR VPWR sky130_fd_sc_hd__decap_3
X_3351_ _2006_ _0082_ VGND VGND VPWR VPWR _0464_ sky130_fd_sc_hd__and2_1
X_2302_ _1519_ VGND VGND VPWR VPWR _0006_ sky130_fd_sc_hd__clkbuf_1
XTAP_702 VGND VPWR sky130_fd_sc_hd__tapvpwrvgnd_1
XTAP_713 VGND VPWR sky130_fd_sc_hd__tapvpwrvgnd_1
XTAP_724 VGND VPWR sky130_fd_sc_hd__tapvpwrvgnd_1
XTAP_768 VGND VPWR sky130_fd_sc_hd__tapvpwrvgnd_1
X_3282_ net92 _0306_ _0394_ _0395_ VGND VGND VPWR VPWR _0396_ sky130_fd_sc_hd__a211o_1
XTAP_735 VGND VPWR sky130_fd_sc_hd__tapvpwrvgnd_1
XTAP_746 VGND VPWR sky130_fd_sc_hd__tapvpwrvgnd_1
XTAP_757 VGND VPWR sky130_fd_sc_hd__tapvpwrvgnd_1
XTAP_779 VGND VPWR sky130_fd_sc_hd__tapvpwrvgnd_1
X_2233_ net57 add_tmp\[29\] VGND VGND VPWR VPWR _1457_ sky130_fd_sc_hd__nand2_1
X_2164_ net67 add_tmp\[5\] VGND VGND VPWR VPWR _1222_ sky130_fd_sc_hd__nand2_1
XFILLER_0_75_212 VPWR VGND VPWR VGND sky130_ef_sc_hd__decap_12
XFILLER_0_0_65 VGND VGND VPWR VPWR sky130_fd_sc_hd__fill_1
XFILLER_0_48_459 VGND VGND VPWR VPWR sky130_fd_sc_hd__decap_4
XFILLER_0_28_183 VGND VGND VPWR VPWR sky130_fd_sc_hd__fill_1
X_2997_ _0110_ _0113_ VGND VGND VPWR VPWR _0114_ sky130_fd_sc_hd__nor2_2
XFILLER_0_43_164 VGND VGND VPWR VPWR sky130_fd_sc_hd__decap_4
XFILLER_0_43_175 VGND VGND VPWR VPWR sky130_fd_sc_hd__fill_1
XFILLER_0_31_359 VGND VGND VPWR VPWR sky130_fd_sc_hd__decap_4
X_3618_ _0655_ _0656_ VGND VGND VPWR VPWR _0728_ sky130_fd_sc_hd__nor2_1
X_3549_ _0658_ _0659_ VGND VGND VPWR VPWR _0660_ sky130_fd_sc_hd__xnor2_2
XFILLER_0_66_201 VGND VGND VPWR VPWR sky130_fd_sc_hd__decap_3
XFILLER_0_26_109 VGND VGND VPWR VPWR sky130_fd_sc_hd__decap_6
XFILLER_0_66_256 VGND VGND VPWR VPWR sky130_fd_sc_hd__decap_6
XFILLER_0_34_197 VPWR VGND VPWR VGND sky130_ef_sc_hd__decap_12
XFILLER_0_66_29 VGND VGND VPWR VPWR sky130_fd_sc_hd__decap_3
XFILLER_0_15_55 VGND VGND VPWR VPWR sky130_fd_sc_hd__fill_1
XFILLER_0_15_77 VPWR VGND VPWR VGND sky130_ef_sc_hd__decap_12
X_2920_ _1936_ _1866_ _2093_ _2094_ VGND VGND VPWR VPWR _2095_ sky130_fd_sc_hd__nand4_4
X_2851_ _2024_ _2025_ _2026_ VGND VGND VPWR VPWR _2027_ sky130_fd_sc_hd__nand3_2
XFILLER_0_31_65 VGND VGND VPWR VPWR sky130_fd_sc_hd__decap_3
X_2782_ _1797_ VGND VGND VPWR VPWR _1959_ sky130_fd_sc_hd__buf_2
XFILLER_0_13_337 VGND VGND VPWR VPWR sky130_fd_sc_hd__decap_3
X_3403_ _0490_ _0497_ _0495_ VGND VGND VPWR VPWR _0515_ sky130_fd_sc_hd__a21oi_1
XFILLER_0_0_275 VGND VGND VPWR VPWR sky130_fd_sc_hd__fill_1
XTAP_510 VGND VPWR sky130_fd_sc_hd__tapvpwrvgnd_1
XTAP_521 VGND VPWR sky130_fd_sc_hd__tapvpwrvgnd_1
XTAP_532 VGND VPWR sky130_fd_sc_hd__tapvpwrvgnd_1
XTAP_543 VGND VPWR sky130_fd_sc_hd__tapvpwrvgnd_1
X_3334_ _0100_ _1817_ _0112_ _0354_ VGND VGND VPWR VPWR _0447_ sky130_fd_sc_hd__nand4_2
XTAP_554 VGND VPWR sky130_fd_sc_hd__tapvpwrvgnd_1
XTAP_565 VGND VPWR sky130_fd_sc_hd__tapvpwrvgnd_1
XTAP_576 VGND VPWR sky130_fd_sc_hd__tapvpwrvgnd_1
X_3265_ _0373_ _0374_ _0377_ VGND VGND VPWR VPWR _0379_ sky130_fd_sc_hd__a21o_1
X_2216_ _1438_ _1439_ VGND VGND VPWR VPWR _1440_ sky130_fd_sc_hd__or2b_1
XTAP_587 VGND VPWR sky130_fd_sc_hd__tapvpwrvgnd_1
XTAP_598 VGND VPWR sky130_fd_sc_hd__tapvpwrvgnd_1
X_3196_ _0227_ _0235_ _0309_ _0310_ VGND VGND VPWR VPWR _0311_ sky130_fd_sc_hd__o211ai_2
X_2147_ net70 add_tmp\[8\] VGND VGND VPWR VPWR _1038_ sky130_fd_sc_hd__nor2_1
XFILLER_0_48_201 VGND VGND VPWR VPWR sky130_fd_sc_hd__fill_1
XFILLER_0_72_83 VGND VGND VPWR VPWR sky130_fd_sc_hd__fill_1
XFILLER_0_8_353 VGND VGND VPWR VPWR sky130_fd_sc_hd__fill_1
XFILLER_0_44_462 VGND VGND VPWR VPWR sky130_fd_sc_hd__fill_1
XFILLER_0_71_281 VPWR VGND VPWR VGND sky130_ef_sc_hd__decap_12
XFILLER_0_39_201 VGND VGND VPWR VPWR sky130_fd_sc_hd__decap_6
XFILLER_0_39_223 VGND VGND VPWR VPWR sky130_fd_sc_hd__fill_1
XFILLER_0_54_215 VPWR VGND VPWR VGND sky130_ef_sc_hd__decap_12
XFILLER_0_22_134 VGND VGND VPWR VPWR sky130_fd_sc_hd__decap_6
X_3050_ _1927_ _0165_ _0083_ _1842_ VGND VGND VPWR VPWR _0166_ sky130_fd_sc_hd__a22oi_1
X_3952_ _1060_ _1079_ VGND VGND VPWR VPWR _1082_ sky130_fd_sc_hd__nand2_1
X_3883_ _1002_ _1003_ _1004_ VGND VGND VPWR VPWR _1007_ sky130_fd_sc_hd__and3_1
X_2903_ _1879_ _1880_ _2077_ _1898_ VGND VGND VPWR VPWR _2078_ sky130_fd_sc_hd__nand4_2
X_2834_ net28 VGND VGND VPWR VPWR _2010_ sky130_fd_sc_hd__clkbuf_2
XFILLER_0_5_345 VGND VGND VPWR VPWR sky130_fd_sc_hd__fill_2
XFILLER_0_41_432 VPWR VGND VPWR VGND sky130_ef_sc_hd__decap_12
X_2765_ net18 VGND VGND VPWR VPWR _1942_ sky130_fd_sc_hd__clkbuf_2
XFILLER_0_53_281 VPWR VGND VPWR VGND sky130_ef_sc_hd__decap_12
X_2696_ _1826_ _1828_ _1831_ VGND VGND VPWR VPWR _1874_ sky130_fd_sc_hd__a21bo_1
XFILLER_0_13_189 VGND VGND VPWR VPWR sky130_fd_sc_hd__decap_3
XTAP_340 VGND VPWR sky130_fd_sc_hd__tapvpwrvgnd_1
XTAP_351 VGND VPWR sky130_fd_sc_hd__tapvpwrvgnd_1
X_3317_ _2096_ VGND VGND VPWR VPWR _0430_ sky130_fd_sc_hd__clkbuf_2
XTAP_362 VGND VPWR sky130_fd_sc_hd__tapvpwrvgnd_1
XTAP_373 VGND VPWR sky130_fd_sc_hd__tapvpwrvgnd_1
XTAP_384 VGND VPWR sky130_fd_sc_hd__tapvpwrvgnd_1
X_4297_ clknet_3_3__leaf_clk _0042_ net35 VGND VGND VPWR VPWR add_tmp\[4\] sky130_fd_sc_hd__dfrtp_1
XTAP_395 VGND VPWR sky130_fd_sc_hd__tapvpwrvgnd_1
X_3248_ _0352_ _0361_ VGND VGND VPWR VPWR _0362_ sky130_fd_sc_hd__xor2_2
X_3179_ _2077_ _1867_ _1868_ _1820_ VGND VGND VPWR VPWR _0294_ sky130_fd_sc_hd__nand4_2
Xrebuffer20 net92 VGND VGND VPWR VPWR net93 sky130_fd_sc_hd__clkbuf_1
XPHY_13 VGND VGND VPWR VPWR sky130_fd_sc_hd__decap_3
Xrebuffer53 _1757_ VGND VGND VPWR VPWR net126 sky130_fd_sc_hd__clkbuf_1
Xrebuffer64 _1765_ VGND VGND VPWR VPWR net150 sky130_fd_sc_hd__dlymetal6s2s_1
Xrebuffer31 _0194_ VGND VGND VPWR VPWR net104 sky130_fd_sc_hd__clkbuf_1
Xrebuffer42 _0105_ VGND VGND VPWR VPWR net115 sky130_fd_sc_hd__clkbuf_2
XFILLER_0_68_307 VGND VGND VPWR VPWR sky130_fd_sc_hd__fill_1
XPHY_35 VGND VGND VPWR VPWR sky130_fd_sc_hd__decap_3
XPHY_24 VGND VGND VPWR VPWR sky130_fd_sc_hd__decap_3
XPHY_46 VGND VGND VPWR VPWR sky130_fd_sc_hd__decap_3
XPHY_57 VGND VGND VPWR VPWR sky130_fd_sc_hd__decap_3
XPHY_68 VGND VGND VPWR VPWR sky130_fd_sc_hd__decap_3
XPHY_79 VGND VGND VPWR VPWR sky130_fd_sc_hd__decap_3
XFILLER_0_76_384 VGND VGND VPWR VPWR sky130_fd_sc_hd__fill_1
XFILLER_0_36_226 VPWR VGND VPWR VGND sky130_ef_sc_hd__decap_12
XFILLER_0_32_421 VGND VGND VPWR VPWR sky130_fd_sc_hd__decap_8
XFILLER_0_4_3 VPWR VGND VPWR VGND sky130_ef_sc_hd__decap_12
XFILLER_0_67_373 VGND VGND VPWR VPWR sky130_fd_sc_hd__decap_4
XFILLER_0_27_248 VGND VGND VPWR VPWR sky130_fd_sc_hd__decap_4
XFILLER_0_23_432 VPWR VGND VPWR VGND sky130_ef_sc_hd__decap_12
XFILLER_0_42_229 VGND VGND VPWR VPWR sky130_fd_sc_hd__fill_2
XFILLER_0_2_337 VGND VGND VPWR VPWR sky130_fd_sc_hd__decap_8
X_2550_ net149 _1728_ _1731_ VGND VGND VPWR VPWR _1732_ sky130_fd_sc_hd__a21o_1
XFILLER_0_50_251 VGND VGND VPWR VPWR sky130_fd_sc_hd__fill_1
X_2481_ net10 VGND VGND VPWR VPWR _1666_ sky130_fd_sc_hd__clkbuf_2
X_4220_ _1367_ _1369_ VGND VGND VPWR VPWR _1370_ sky130_fd_sc_hd__xnor2_1
X_4151_ _1294_ _1295_ VGND VGND VPWR VPWR _1296_ sky130_fd_sc_hd__nor2_1
X_4082_ _1159_ _1162_ VGND VGND VPWR VPWR _1223_ sky130_fd_sc_hd__or2b_1
XFILLER_0_37_53 VGND VGND VPWR VPWR sky130_fd_sc_hd__decap_3
XFILLER_0_37_64 VGND VGND VPWR VPWR sky130_fd_sc_hd__decap_8
X_3102_ _0130_ _0180_ _0216_ _0217_ VGND VGND VPWR VPWR _0218_ sky130_fd_sc_hd__a211oi_2
X_3033_ _0149_ VGND VGND VPWR VPWR _0050_ sky130_fd_sc_hd__clkbuf_1
XFILLER_0_53_96 VGND VGND VPWR VPWR sky130_fd_sc_hd__decap_4
X_3935_ _0430_ _0342_ _0155_ _0470_ VGND VGND VPWR VPWR _1063_ sky130_fd_sc_hd__and4_1
X_3866_ _0988_ VGND VGND VPWR VPWR _0060_ sky130_fd_sc_hd__clkbuf_1
X_3797_ _1974_ _2037_ _0912_ _0534_ VGND VGND VPWR VPWR _0913_ sky130_fd_sc_hd__and4_1
X_2817_ _1919_ _1982_ VGND VGND VPWR VPWR _1993_ sky130_fd_sc_hd__and2b_1
X_2748_ add_tmp\[8\] _1925_ _1490_ VGND VGND VPWR VPWR _1926_ sky130_fd_sc_hd__mux2_1
X_2679_ _1801_ _1855_ _1856_ VGND VGND VPWR VPWR _1858_ sky130_fd_sc_hd__nand3_1
XTAP_170 VGND VPWR sky130_fd_sc_hd__tapvpwrvgnd_1
XTAP_181 VGND VPWR sky130_fd_sc_hd__tapvpwrvgnd_1
XTAP_192 VGND VPWR sky130_fd_sc_hd__tapvpwrvgnd_1
XFILLER_0_68_159 VGND VGND VPWR VPWR sky130_fd_sc_hd__decap_4
XFILLER_0_49_373 VPWR VGND VPWR VGND sky130_ef_sc_hd__decap_12
XFILLER_0_64_321 VGND VGND VPWR VPWR sky130_fd_sc_hd__fill_1
XFILLER_0_64_365 VGND VGND VPWR VPWR sky130_fd_sc_hd__decap_8
XFILLER_0_24_229 VGND VGND VPWR VPWR sky130_fd_sc_hd__decap_6
XFILLER_0_32_251 VGND VGND VPWR VPWR sky130_fd_sc_hd__fill_1
XFILLER_0_32_295 VGND VGND VPWR VPWR sky130_fd_sc_hd__fill_2
XFILLER_0_74_29 VPWR VGND VPWR VGND sky130_ef_sc_hd__decap_12
XFILLER_0_23_33 VGND VGND VPWR VPWR sky130_fd_sc_hd__decap_6
XFILLER_0_23_77 VGND VGND VPWR VPWR sky130_fd_sc_hd__fill_2
X_3720_ _0672_ _0751_ _0828_ VGND VGND VPWR VPWR _0829_ sky130_fd_sc_hd__a21bo_1
XFILLER_0_67_181 VGND VGND VPWR VPWR sky130_fd_sc_hd__decap_3
X_3651_ _0757_ _0164_ _0758_ _0759_ VGND VGND VPWR VPWR _0760_ sky130_fd_sc_hd__nand4_2
X_2602_ net28 VGND VGND VPWR VPWR _1782_ sky130_fd_sc_hd__clkbuf_2
X_3582_ _0685_ _0686_ _0691_ VGND VGND VPWR VPWR _0692_ sky130_fd_sc_hd__a21o_1
XFILLER_0_2_134 VGND VGND VPWR VPWR sky130_fd_sc_hd__decap_6
XFILLER_0_23_262 VPWR VGND VPWR VGND sky130_ef_sc_hd__decap_12
X_2533_ net29 VGND VGND VPWR VPWR _1715_ sky130_fd_sc_hd__clkbuf_2
X_2464_ _0842_ _0864_ _1480_ _1482_ VGND VGND VPWR VPWR _1651_ sky130_fd_sc_hd__a211oi_1
X_2395_ _1427_ _1594_ VGND VGND VPWR VPWR _1595_ sky130_fd_sc_hd__xor2_1
X_4203_ _1305_ VGND VGND VPWR VPWR _1353_ sky130_fd_sc_hd__inv_2
XFILLER_0_47_6 VGND VGND VPWR VPWR sky130_fd_sc_hd__decap_8
XFILLER_0_48_74 VGND VGND VPWR VPWR sky130_fd_sc_hd__decap_6
X_4134_ _1266_ _1267_ VGND VGND VPWR VPWR _1278_ sky130_fd_sc_hd__or2b_1
X_4065_ _1127_ _1203_ VGND VGND VPWR VPWR _1204_ sky130_fd_sc_hd__xor2_1
XFILLER_0_3_76 VGND VGND VPWR VPWR sky130_fd_sc_hd__decap_6
XFILLER_0_64_73 VGND VGND VPWR VPWR sky130_fd_sc_hd__decap_8
X_3016_ _0130_ _0131_ _0106_ VGND VGND VPWR VPWR _0133_ sky130_fd_sc_hd__a21oi_2
X_3918_ _0967_ _0989_ _1043_ _1044_ VGND VGND VPWR VPWR _1045_ sky130_fd_sc_hd__a211oi_2
XFILLER_0_46_365 VGND VGND VPWR VPWR sky130_fd_sc_hd__decap_8
X_3849_ _0958_ _0959_ _0969_ VGND VGND VPWR VPWR _0970_ sky130_fd_sc_hd__o21ai_2
XFILLER_0_61_335 VGND VGND VPWR VPWR sky130_fd_sc_hd__fill_1
XFILLER_0_14_251 VGND VGND VPWR VPWR sky130_fd_sc_hd__fill_1
XFILLER_0_37_321 VPWR VGND VPWR VGND sky130_ef_sc_hd__decap_12
XFILLER_0_49_192 VGND VGND VPWR VPWR sky130_fd_sc_hd__decap_8
XFILLER_0_64_195 VGND VGND VPWR VPWR sky130_fd_sc_hd__fill_1
XFILLER_0_60_390 VGND VGND VPWR VPWR sky130_fd_sc_hd__fill_1
X_2180_ _0940_ _0951_ _1372_ _1383_ _0918_ VGND VGND VPWR VPWR _1393_ sky130_fd_sc_hd__o311a_1
XFILLER_0_18_88 VPWR VGND VPWR VGND sky130_ef_sc_hd__decap_12
XFILLER_0_34_21 VGND VGND VPWR VPWR sky130_fd_sc_hd__decap_6
XFILLER_0_34_54 VPWR VGND VPWR VGND sky130_ef_sc_hd__decap_12
XFILLER_0_75_449 VPWR VGND VPWR VGND sky130_ef_sc_hd__decap_12
XFILLER_0_7_237 VPWR VGND VPWR VGND sky130_ef_sc_hd__decap_12
XFILLER_0_28_365 VGND VGND VPWR VPWR sky130_fd_sc_hd__fill_2
XFILLER_0_43_335 VGND VGND VPWR VPWR sky130_fd_sc_hd__fill_1
XFILLER_0_50_75 VGND VGND VPWR VPWR sky130_fd_sc_hd__decap_8
X_3703_ _0677_ _0726_ VGND VGND VPWR VPWR _0812_ sky130_fd_sc_hd__nor2_1
X_3634_ _0678_ _0696_ _0694_ VGND VGND VPWR VPWR _0743_ sky130_fd_sc_hd__a21oi_1
XFILLER_0_50_97 VGND VGND VPWR VPWR sky130_fd_sc_hd__decap_4
XFILLER_0_70_165 VGND VGND VPWR VPWR sky130_fd_sc_hd__decap_8
XFILLER_0_11_210 VPWR VGND VPWR VGND sky130_ef_sc_hd__decap_12
X_3565_ _0672_ _0674_ VGND VGND VPWR VPWR _0675_ sky130_fd_sc_hd__nor2_1
X_2516_ _1698_ VGND VGND VPWR VPWR _1699_ sky130_fd_sc_hd__inv_2
XFILLER_0_59_95 VGND VGND VPWR VPWR sky130_fd_sc_hd__decap_3
X_3496_ _0518_ _0606_ VGND VGND VPWR VPWR _0607_ sky130_fd_sc_hd__xnor2_2
X_2447_ _1637_ VGND VGND VPWR VPWR _0033_ sky130_fd_sc_hd__clkbuf_1
XFILLER_0_45_3 VGND VGND VPWR VPWR sky130_fd_sc_hd__decap_8
X_2378_ _1503_ VGND VGND VPWR VPWR _1581_ sky130_fd_sc_hd__buf_2
X_4117_ _1258_ _1259_ VGND VGND VPWR VPWR _1260_ sky130_fd_sc_hd__nor2_1
X_4048_ _1184_ _1152_ VGND VGND VPWR VPWR _1185_ sky130_fd_sc_hd__nor2_1
XFILLER_0_19_310 VGND VGND VPWR VPWR sky130_fd_sc_hd__decap_3
XFILLER_0_71_19 VPWR VGND VPWR VGND sky130_ef_sc_hd__decap_12
XFILLER_0_29_107 VGND VGND VPWR VPWR sky130_fd_sc_hd__decap_4
XFILLER_0_57_416 VPWR VGND VPWR VGND sky130_ef_sc_hd__decap_12
XFILLER_0_57_449 VPWR VGND VPWR VGND sky130_ef_sc_hd__decap_12
XFILLER_0_37_140 VGND VGND VPWR VPWR sky130_fd_sc_hd__fill_2
XFILLER_0_25_324 VGND VGND VPWR VPWR sky130_fd_sc_hd__fill_2
XFILLER_0_37_173 VGND VGND VPWR VPWR sky130_fd_sc_hd__decap_4
XFILLER_0_25_335 VGND VGND VPWR VPWR sky130_fd_sc_hd__fill_1
XFILLER_0_37_195 VGND VGND VPWR VPWR sky130_fd_sc_hd__decap_8
XFILLER_0_33_390 VGND VGND VPWR VPWR sky130_fd_sc_hd__fill_2
X_3350_ _1997_ _0290_ _0369_ _0462_ VGND VGND VPWR VPWR _0463_ sky130_fd_sc_hd__nand4_2
X_2301_ net66 _1518_ _1495_ VGND VGND VPWR VPWR _1519_ sky130_fd_sc_hd__mux2_1
XTAP_703 VGND VPWR sky130_fd_sc_hd__tapvpwrvgnd_1
XTAP_714 VGND VPWR sky130_fd_sc_hd__tapvpwrvgnd_1
XTAP_725 VGND VPWR sky130_fd_sc_hd__tapvpwrvgnd_1
XTAP_736 VGND VPWR sky130_fd_sc_hd__tapvpwrvgnd_1
X_3281_ _0393_ _0365_ _0366_ VGND VGND VPWR VPWR _0395_ sky130_fd_sc_hd__nor3_2
XTAP_747 VGND VPWR sky130_fd_sc_hd__tapvpwrvgnd_1
XTAP_758 VGND VPWR sky130_fd_sc_hd__tapvpwrvgnd_1
XTAP_769 VGND VPWR sky130_fd_sc_hd__tapvpwrvgnd_1
X_2232_ net57 add_tmp\[29\] VGND VGND VPWR VPWR _1456_ sky130_fd_sc_hd__nor2_1
X_2163_ _1081_ _1189_ _1200_ VGND VGND VPWR VPWR _1211_ sky130_fd_sc_hd__a21bo_1
XFILLER_0_31_9 VGND VGND VPWR VPWR sky130_fd_sc_hd__fill_1
XFILLER_0_0_44 VPWR VGND VPWR VGND sky130_ef_sc_hd__decap_12
XFILLER_0_75_279 VGND VGND VPWR VPWR sky130_fd_sc_hd__fill_1
XFILLER_0_75_257 VGND VGND VPWR VPWR sky130_fd_sc_hd__fill_1
X_2996_ _1716_ _0111_ _0112_ _1881_ VGND VGND VPWR VPWR _0113_ sky130_fd_sc_hd__a22oi_2
XFILLER_0_28_195 VGND VGND VPWR VPWR sky130_fd_sc_hd__fill_1
XFILLER_0_43_121 VGND VGND VPWR VPWR sky130_fd_sc_hd__decap_3
XFILLER_0_3_262 VPWR VGND VPWR VGND sky130_ef_sc_hd__decap_12
X_3617_ _0677_ _0726_ VGND VGND VPWR VPWR _0727_ sky130_fd_sc_hd__xor2_1
X_3548_ _0527_ _0584_ _0583_ VGND VGND VPWR VPWR _0659_ sky130_fd_sc_hd__o21ba_1
X_3479_ _0501_ _0503_ _0589_ _0590_ VGND VGND VPWR VPWR _0591_ sky130_fd_sc_hd__o211a_1
XFILLER_0_39_405 VPWR VGND VPWR VGND sky130_ef_sc_hd__decap_12
XFILLER_0_39_427 VPWR VGND VPWR VGND sky130_ef_sc_hd__decap_12
XFILLER_0_39_449 VGND VGND VPWR VPWR sky130_fd_sc_hd__decap_4
XFILLER_0_54_419 VGND VGND VPWR VPWR sky130_fd_sc_hd__fill_1
XFILLER_0_19_151 VPWR VGND VPWR VGND sky130_ef_sc_hd__decap_12
XFILLER_0_34_110 VPWR VGND VPWR VGND sky130_ef_sc_hd__decap_12
XFILLER_0_34_132 VGND VGND VPWR VPWR sky130_fd_sc_hd__decap_8
XFILLER_0_34_176 VPWR VGND VPWR VGND sky130_ef_sc_hd__decap_12
XFILLER_0_66_19 VGND VGND VPWR VPWR sky130_fd_sc_hd__decap_4
XFILLER_0_15_89 VPWR VGND VPWR VGND sky130_ef_sc_hd__decap_12
XFILLER_0_45_419 VGND VGND VPWR VPWR sky130_fd_sc_hd__decap_4
X_2850_ _1933_ _1948_ _1947_ VGND VGND VPWR VPWR _2026_ sky130_fd_sc_hd__a21bo_1
XFILLER_0_57_279 VGND VGND VPWR VPWR sky130_fd_sc_hd__fill_1
X_2781_ _1678_ _1694_ _1897_ _1820_ VGND VGND VPWR VPWR _1958_ sky130_fd_sc_hd__and4_1
XFILLER_0_25_154 VPWR VGND VPWR VGND sky130_ef_sc_hd__decap_12
XFILLER_0_40_102 VPWR VGND VPWR VGND sky130_ef_sc_hd__decap_12
X_3402_ _0514_ VGND VGND VPWR VPWR _0054_ sky130_fd_sc_hd__clkbuf_1
XFILLER_0_21_360 VPWR VGND VPWR VGND sky130_ef_sc_hd__decap_12
XTAP_500 VGND VPWR sky130_fd_sc_hd__tapvpwrvgnd_1
XTAP_511 VGND VPWR sky130_fd_sc_hd__tapvpwrvgnd_1
XTAP_522 VGND VPWR sky130_fd_sc_hd__tapvpwrvgnd_1
XTAP_533 VGND VPWR sky130_fd_sc_hd__tapvpwrvgnd_1
X_3333_ _0445_ _1940_ _0354_ _1959_ VGND VGND VPWR VPWR _0446_ sky130_fd_sc_hd__a22o_1
XTAP_544 VGND VPWR sky130_fd_sc_hd__tapvpwrvgnd_1
XTAP_555 VGND VPWR sky130_fd_sc_hd__tapvpwrvgnd_1
XTAP_566 VGND VPWR sky130_fd_sc_hd__tapvpwrvgnd_1
XFILLER_0_56_41 VGND VGND VPWR VPWR sky130_fd_sc_hd__decap_8
X_3264_ _0373_ _0374_ _0377_ VGND VGND VPWR VPWR _0378_ sky130_fd_sc_hd__nand3_2
X_2215_ net53 add_tmp\[25\] VGND VGND VPWR VPWR _1439_ sky130_fd_sc_hd__nand2_1
XTAP_577 VGND VPWR sky130_fd_sc_hd__tapvpwrvgnd_1
XTAP_588 VGND VPWR sky130_fd_sc_hd__tapvpwrvgnd_1
XTAP_599 VGND VPWR sky130_fd_sc_hd__tapvpwrvgnd_1
X_3195_ _0307_ _0308_ _0238_ VGND VGND VPWR VPWR _0310_ sky130_fd_sc_hd__a21o_1
X_2146_ net71 add_tmp\[9\] VGND VGND VPWR VPWR _1027_ sky130_fd_sc_hd__nor2_1
XFILLER_0_48_213 VGND VGND VPWR VPWR sky130_fd_sc_hd__fill_2
XFILLER_0_48_246 VGND VGND VPWR VPWR sky130_fd_sc_hd__decap_6
XFILLER_0_8_387 VGND VGND VPWR VPWR sky130_fd_sc_hd__fill_1
XFILLER_0_56_290 VGND VGND VPWR VPWR sky130_fd_sc_hd__decap_4
X_2979_ net118 _2109_ net120 VGND VGND VPWR VPWR _0096_ sky130_fd_sc_hd__nand3_2
XFILLER_0_31_102 VGND VGND VPWR VPWR sky130_fd_sc_hd__decap_8
XFILLER_0_71_293 VGND VGND VPWR VPWR sky130_fd_sc_hd__decap_6
XFILLER_0_54_227 VGND VGND VPWR VPWR sky130_fd_sc_hd__decap_8
XFILLER_0_35_430 VGND VGND VPWR VPWR sky130_fd_sc_hd__decap_6
XFILLER_0_26_55 VGND VGND VPWR VPWR sky130_fd_sc_hd__fill_2
X_3951_ _1060_ _1079_ VGND VGND VPWR VPWR _1080_ sky130_fd_sc_hd__or2_1
X_2902_ _1797_ VGND VGND VPWR VPWR _2077_ sky130_fd_sc_hd__clkbuf_2
X_3882_ _1002_ _1003_ _1004_ VGND VGND VPWR VPWR _1006_ sky130_fd_sc_hd__a21oi_1
X_2833_ _2007_ _2008_ VGND VGND VPWR VPWR _2009_ sky130_fd_sc_hd__nand2_1
XFILLER_0_5_335 VGND VGND VPWR VPWR sky130_fd_sc_hd__fill_1
X_2764_ _1936_ _1937_ _1938_ _1940_ VGND VGND VPWR VPWR _1941_ sky130_fd_sc_hd__nand4_4
XFILLER_0_41_444 VGND VGND VPWR VPWR sky130_fd_sc_hd__decap_4
X_2695_ _1869_ _1871_ _1865_ VGND VGND VPWR VPWR _1873_ sky130_fd_sc_hd__a21o_1
XFILLER_0_6_54 VPWR VGND VPWR VGND sky130_ef_sc_hd__decap_12
XFILLER_0_6_43 VGND VGND VPWR VPWR sky130_fd_sc_hd__decap_4
XTAP_330 VGND VPWR sky130_fd_sc_hd__tapvpwrvgnd_1
XTAP_341 VGND VPWR sky130_fd_sc_hd__tapvpwrvgnd_1
X_3316_ _0424_ _0425_ _0427_ VGND VGND VPWR VPWR _0429_ sky130_fd_sc_hd__a21o_1
XFILLER_0_67_62 VPWR VGND VPWR VGND sky130_ef_sc_hd__decap_12
XTAP_352 VGND VPWR sky130_fd_sc_hd__tapvpwrvgnd_1
XTAP_363 VGND VPWR sky130_fd_sc_hd__tapvpwrvgnd_1
XTAP_374 VGND VPWR sky130_fd_sc_hd__tapvpwrvgnd_1
XTAP_385 VGND VPWR sky130_fd_sc_hd__tapvpwrvgnd_1
X_4296_ clknet_3_1__leaf_clk _0041_ net35 VGND VGND VPWR VPWR add_tmp\[3\] sky130_fd_sc_hd__dfrtp_2
XTAP_396 VGND VPWR sky130_fd_sc_hd__tapvpwrvgnd_1
X_3247_ _0359_ _0360_ VGND VGND VPWR VPWR _0361_ sky130_fd_sc_hd__and2b_1
Xrebuffer21 _1758_ VGND VGND VPWR VPWR net94 sky130_fd_sc_hd__clkbuf_1
X_3178_ _1900_ _1870_ _1830_ _2075_ VGND VGND VPWR VPWR _0293_ sky130_fd_sc_hd__a22o_1
Xrebuffer10 net82 VGND VGND VPWR VPWR net83 sky130_fd_sc_hd__buf_1
X_2129_ _0831_ net64 VGND VGND VPWR VPWR _0842_ sky130_fd_sc_hd__nand2_1
Xrebuffer43 _1893_ VGND VGND VPWR VPWR net116 sky130_fd_sc_hd__clkbuf_1
Xrebuffer32 _0089_ VGND VGND VPWR VPWR net105 sky130_fd_sc_hd__clkbuf_1
Xrebuffer54 net126 VGND VGND VPWR VPWR net127 sky130_fd_sc_hd__clkbuf_1
XPHY_36 VGND VGND VPWR VPWR sky130_fd_sc_hd__decap_3
XPHY_25 VGND VGND VPWR VPWR sky130_fd_sc_hd__decap_3
XPHY_14 VGND VGND VPWR VPWR sky130_fd_sc_hd__decap_3
XPHY_47 VGND VGND VPWR VPWR sky130_fd_sc_hd__decap_3
Xrebuffer65 _0242_ VGND VGND VPWR VPWR net151 sky130_fd_sc_hd__dlygate4sd1_1
XPHY_58 VGND VGND VPWR VPWR sky130_fd_sc_hd__decap_3
XPHY_69 VGND VGND VPWR VPWR sky130_fd_sc_hd__decap_3
XFILLER_0_76_363 VGND VGND VPWR VPWR sky130_fd_sc_hd__fill_1
XFILLER_0_8_195 VGND VGND VPWR VPWR sky130_fd_sc_hd__fill_1
XFILLER_0_44_260 VGND VGND VPWR VPWR sky130_fd_sc_hd__decap_3
XFILLER_0_59_308 VGND VGND VPWR VPWR sky130_fd_sc_hd__fill_2
XFILLER_0_27_216 VGND VGND VPWR VPWR sky130_fd_sc_hd__decap_4
XFILLER_0_27_238 VGND VGND VPWR VPWR sky130_fd_sc_hd__decap_3
XFILLER_0_23_444 VGND VGND VPWR VPWR sky130_fd_sc_hd__decap_4
X_2480_ net130 _1656_ _1665_ VGND VGND VPWR VPWR _0038_ sky130_fd_sc_hd__a21o_1
X_4150_ _1285_ _1293_ VGND VGND VPWR VPWR _1295_ sky130_fd_sc_hd__nor2_1
X_3101_ _0215_ _0201_ _0202_ VGND VGND VPWR VPWR _0217_ sky130_fd_sc_hd__and3_1
X_4081_ _1219_ _1220_ VGND VGND VPWR VPWR _1221_ sky130_fd_sc_hd__xnor2_1
X_3032_ add_tmp\[12\] _0148_ _1991_ VGND VGND VPWR VPWR _0149_ sky130_fd_sc_hd__mux2_1
XFILLER_0_77_127 VGND VGND VPWR VPWR sky130_fd_sc_hd__fill_2
X_3934_ _0534_ _0156_ _0471_ _0431_ VGND VGND VPWR VPWR _1062_ sky130_fd_sc_hd__a22o_1
XFILLER_0_73_300 VGND VGND VPWR VPWR sky130_fd_sc_hd__decap_6
X_3865_ add_tmp\[22\] _0987_ _0596_ VGND VGND VPWR VPWR _0988_ sky130_fd_sc_hd__mux2_1
X_2816_ _1992_ VGND VGND VPWR VPWR _0047_ sky130_fd_sc_hd__clkbuf_1
X_3796_ _0431_ VGND VGND VPWR VPWR _0912_ sky130_fd_sc_hd__dlymetal6s2s_1
XFILLER_0_26_271 VGND VGND VPWR VPWR sky130_fd_sc_hd__fill_2
X_2747_ _1923_ _1924_ VGND VGND VPWR VPWR _1925_ sky130_fd_sc_hd__nor2_1
XFILLER_0_75_3 VPWR VGND VPWR VGND sky130_ef_sc_hd__decap_12
X_2678_ _1855_ _1856_ _1801_ VGND VGND VPWR VPWR _1857_ sky130_fd_sc_hd__a21oi_1
XFILLER_0_1_393 VPWR VGND VPWR VGND sky130_ef_sc_hd__decap_12
XTAP_160 VGND VPWR sky130_fd_sc_hd__tapvpwrvgnd_1
X_4279_ clknet_3_5__leaf_clk _0024_ net35 VGND VGND VPWR VPWR net50 sky130_fd_sc_hd__dfrtp_1
XTAP_171 VGND VPWR sky130_fd_sc_hd__tapvpwrvgnd_1
XTAP_182 VGND VPWR sky130_fd_sc_hd__tapvpwrvgnd_1
XTAP_193 VGND VPWR sky130_fd_sc_hd__tapvpwrvgnd_1
XFILLER_0_76_160 VGND VGND VPWR VPWR sky130_fd_sc_hd__fill_1
XFILLER_0_49_385 VGND VGND VPWR VPWR sky130_fd_sc_hd__decap_6
XFILLER_0_64_300 VGND VGND VPWR VPWR sky130_fd_sc_hd__decap_8
XFILLER_0_64_355 VGND VGND VPWR VPWR sky130_fd_sc_hd__decap_8
XFILLER_0_64_377 VGND VGND VPWR VPWR sky130_fd_sc_hd__fill_1
XFILLER_0_17_271 VGND VGND VPWR VPWR sky130_fd_sc_hd__decap_6
XFILLER_0_20_425 VGND VGND VPWR VPWR sky130_fd_sc_hd__fill_1
X_3650_ _0249_ _0633_ _0371_ _0340_ VGND VGND VPWR VPWR _0759_ sky130_fd_sc_hd__nand4_2
X_2601_ _1777_ _1778_ _1779_ VGND VGND VPWR VPWR _1781_ sky130_fd_sc_hd__a21o_1
X_3581_ _0689_ _0690_ VGND VGND VPWR VPWR _0691_ sky130_fd_sc_hd__xnor2_1
Xrebuffer1 net112 VGND VGND VPWR VPWR net74 sky130_fd_sc_hd__clkbuf_1
XFILLER_0_23_274 VGND VGND VPWR VPWR sky130_fd_sc_hd__decap_6
X_2532_ _1664_ _1707_ _1705_ VGND VGND VPWR VPWR _1714_ sky130_fd_sc_hd__nand3_1
XFILLER_0_11_447 VGND VGND VPWR VPWR sky130_fd_sc_hd__fill_1
XFILLER_0_61_9 VGND VGND VPWR VPWR sky130_fd_sc_hd__decap_6
X_4202_ _1344_ _1350_ VGND VGND VPWR VPWR _1352_ sky130_fd_sc_hd__xnor2_1
X_2463_ _1480_ _1482_ _0842_ _0864_ VGND VGND VPWR VPWR _1650_ sky130_fd_sc_hd__o211a_1
X_2394_ _1430_ _1590_ _1421_ _1420_ VGND VGND VPWR VPWR _1594_ sky130_fd_sc_hd__a31oi_2
X_4133_ net136 _1656_ _1277_ VGND VGND VPWR VPWR _0065_ sky130_fd_sc_hd__a21o_1
X_4064_ _1186_ _1202_ VGND VGND VPWR VPWR _1203_ sky130_fd_sc_hd__xnor2_1
XFILLER_0_3_55 VGND VGND VPWR VPWR sky130_fd_sc_hd__fill_1
XFILLER_0_3_88 VGND VGND VPWR VPWR sky130_fd_sc_hd__decap_3
X_3015_ _0106_ _0130_ _0131_ VGND VGND VPWR VPWR _0132_ sky130_fd_sc_hd__and3_1
XFILLER_0_64_85 VGND VGND VPWR VPWR sky130_fd_sc_hd__decap_8
XFILLER_0_65_108 VGND VGND VPWR VPWR sky130_fd_sc_hd__decap_4
XFILLER_0_46_322 VPWR VGND VPWR VGND sky130_ef_sc_hd__decap_12
X_3917_ _1041_ _1042_ _0958_ _0990_ VGND VGND VPWR VPWR _1044_ sky130_fd_sc_hd__a211oi_2
X_3848_ _0888_ _0968_ VGND VGND VPWR VPWR _0969_ sky130_fd_sc_hd__xnor2_2
X_3779_ _0892_ _0893_ VGND VGND VPWR VPWR _0894_ sky130_fd_sc_hd__nor2_1
XFILLER_0_14_296 VGND VGND VPWR VPWR sky130_fd_sc_hd__decap_4
XFILLER_0_37_300 VGND VGND VPWR VPWR sky130_fd_sc_hd__decap_8
XFILLER_0_37_333 VGND VGND VPWR VPWR sky130_fd_sc_hd__decap_3
XFILLER_0_52_303 VGND VGND VPWR VPWR sky130_fd_sc_hd__decap_4
XFILLER_0_20_244 VGND VGND VPWR VPWR sky130_fd_sc_hd__decap_8
XFILLER_0_34_66 VGND VGND VPWR VPWR sky130_fd_sc_hd__fill_1
XFILLER_0_7_216 VGND VGND VPWR VPWR sky130_fd_sc_hd__decap_8
XFILLER_0_7_249 VGND VGND VPWR VPWR sky130_fd_sc_hd__decap_8
XFILLER_0_50_54 VGND VGND VPWR VPWR sky130_fd_sc_hd__decap_4
XFILLER_0_50_65 VGND VGND VPWR VPWR sky130_fd_sc_hd__decap_6
X_3702_ _0809_ _0810_ VGND VGND VPWR VPWR _0811_ sky130_fd_sc_hd__nand2_1
XFILLER_0_55_196 VGND VGND VPWR VPWR sky130_fd_sc_hd__fill_1
X_3633_ _0671_ _0675_ _0741_ VGND VGND VPWR VPWR _0742_ sky130_fd_sc_hd__a21o_1
XFILLER_0_70_133 VGND VGND VPWR VPWR sky130_fd_sc_hd__decap_3
XFILLER_0_11_222 VGND VGND VPWR VPWR sky130_fd_sc_hd__fill_2
X_3564_ _0204_ _0520_ _0618_ _0673_ _0617_ VGND VGND VPWR VPWR _0674_ sky130_fd_sc_hd__a311oi_2
XFILLER_0_59_52 VGND VGND VPWR VPWR sky130_fd_sc_hd__decap_4
X_2515_ _1657_ _1671_ _1678_ _1697_ VGND VGND VPWR VPWR _1698_ sky130_fd_sc_hd__and4_1
X_3495_ _0604_ _0605_ VGND VGND VPWR VPWR _0606_ sky130_fd_sc_hd__nor2_1
X_2446_ net60 _1635_ _1636_ VGND VGND VPWR VPWR _1637_ sky130_fd_sc_hd__mux2_1
XFILLER_0_75_51 VGND VGND VPWR VPWR sky130_fd_sc_hd__decap_4
X_4116_ _1131_ _1257_ _1190_ _1191_ _1188_ VGND VGND VPWR VPWR _1259_ sky130_fd_sc_hd__o221a_1
X_2377_ _1501_ VGND VGND VPWR VPWR _1580_ sky130_fd_sc_hd__buf_2
XFILLER_0_38_3 VGND VGND VPWR VPWR sky130_fd_sc_hd__decap_3
X_4047_ _1127_ VGND VGND VPWR VPWR _1184_ sky130_fd_sc_hd__dlymetal6s2s_1
XFILLER_0_19_333 VGND VGND VPWR VPWR sky130_fd_sc_hd__decap_3
XFILLER_0_61_155 VGND VGND VPWR VPWR sky130_fd_sc_hd__decap_8
XFILLER_0_42_380 VGND VGND VPWR VPWR sky130_fd_sc_hd__fill_1
XFILLER_0_69_211 VGND VGND VPWR VPWR sky130_fd_sc_hd__fill_2
XFILLER_0_57_428 VPWR VGND VPWR VGND sky130_ef_sc_hd__decap_12
XFILLER_0_69_288 VPWR VGND VPWR VGND sky130_ef_sc_hd__decap_12
XFILLER_0_65_461 VGND VGND VPWR VPWR sky130_fd_sc_hd__fill_2
XFILLER_0_20_68 VPWR VGND VPWR VGND sky130_ef_sc_hd__decap_12
XFILLER_0_40_306 VGND VGND VPWR VPWR sky130_fd_sc_hd__fill_2
X_2300_ _1514_ add_tmp\[4\] _1515_ _1517_ VGND VGND VPWR VPWR _1518_ sky130_fd_sc_hd__a22o_1
XTAP_704 VGND VPWR sky130_fd_sc_hd__tapvpwrvgnd_1
XTAP_715 VGND VPWR sky130_fd_sc_hd__tapvpwrvgnd_1
X_3280_ _0365_ _0366_ _0393_ VGND VGND VPWR VPWR _0394_ sky130_fd_sc_hd__o21a_1
X_2231_ _1447_ _1453_ _1454_ _1441_ VGND VGND VPWR VPWR _1455_ sky130_fd_sc_hd__o211a_1
XTAP_726 VGND VPWR sky130_fd_sc_hd__tapvpwrvgnd_1
XTAP_737 VGND VPWR sky130_fd_sc_hd__tapvpwrvgnd_1
XTAP_748 VGND VPWR sky130_fd_sc_hd__tapvpwrvgnd_1
XTAP_759 VGND VPWR sky130_fd_sc_hd__tapvpwrvgnd_1
X_2162_ net66 add_tmp\[4\] VGND VGND VPWR VPWR _1200_ sky130_fd_sc_hd__nand2_1
XFILLER_0_24_9 VGND VGND VPWR VPWR sky130_fd_sc_hd__decap_3
XFILLER_0_75_225 VGND VGND VPWR VPWR sky130_fd_sc_hd__decap_4
XFILLER_0_28_141 VGND VGND VPWR VPWR sky130_fd_sc_hd__fill_1
X_2995_ _1939_ VGND VGND VPWR VPWR _0112_ sky130_fd_sc_hd__buf_2
XFILLER_0_9_65 VGND VGND VPWR VPWR sky130_fd_sc_hd__decap_8
XFILLER_0_31_306 VGND VGND VPWR VPWR sky130_fd_sc_hd__fill_2
XFILLER_0_9_98 VGND VGND VPWR VPWR sky130_fd_sc_hd__decap_4
XFILLER_0_3_241 VPWR VGND VPWR VGND sky130_ef_sc_hd__decap_12
X_3616_ _0723_ _0725_ VGND VGND VPWR VPWR _0726_ sky130_fd_sc_hd__xnor2_2
XFILLER_0_3_274 VGND VGND VPWR VPWR sky130_fd_sc_hd__decap_6
X_3547_ _0607_ _0657_ VGND VGND VPWR VPWR _0658_ sky130_fd_sc_hd__xnor2_2
X_3478_ _0587_ _0588_ _0515_ VGND VGND VPWR VPWR _0590_ sky130_fd_sc_hd__o21ai_1
X_2429_ net56 _1622_ _1597_ VGND VGND VPWR VPWR _1623_ sky130_fd_sc_hd__mux2_1
XFILLER_0_39_417 VGND VGND VPWR VPWR sky130_fd_sc_hd__decap_4
XFILLER_0_39_439 VGND VGND VPWR VPWR sky130_fd_sc_hd__decap_8
XFILLER_0_34_122 VGND VGND VPWR VPWR sky130_fd_sc_hd__decap_6
XFILLER_0_34_188 VGND VGND VPWR VPWR sky130_fd_sc_hd__decap_8
XFILLER_0_15_391 VGND VGND VPWR VPWR sky130_fd_sc_hd__fill_1
XFILLER_0_72_217 VGND VGND VPWR VPWR sky130_fd_sc_hd__fill_1
X_2780_ _1955_ _1956_ _1884_ _1883_ VGND VGND VPWR VPWR _1957_ sky130_fd_sc_hd__a31o_1
XFILLER_0_13_306 VGND VGND VPWR VPWR sky130_fd_sc_hd__fill_2
XFILLER_0_25_144 VGND VGND VPWR VPWR sky130_fd_sc_hd__decap_6
XFILLER_0_25_166 VGND VGND VPWR VPWR sky130_fd_sc_hd__fill_2
XFILLER_0_13_328 VGND VGND VPWR VPWR sky130_fd_sc_hd__decap_8
XFILLER_0_40_114 VGND VGND VPWR VPWR sky130_fd_sc_hd__decap_3
X_3401_ add_tmp\[16\] _0513_ _1991_ VGND VGND VPWR VPWR _0514_ sky130_fd_sc_hd__mux2_1
XFILLER_0_0_233 VPWR VGND VPWR VGND sky130_ef_sc_hd__decap_12
XFILLER_0_21_372 VGND VGND VPWR VPWR sky130_fd_sc_hd__fill_1
X_3332_ _1816_ VGND VGND VPWR VPWR _0445_ sky130_fd_sc_hd__clkbuf_2
XTAP_501 VGND VPWR sky130_fd_sc_hd__tapvpwrvgnd_1
XTAP_512 VGND VPWR sky130_fd_sc_hd__tapvpwrvgnd_1
XTAP_523 VGND VPWR sky130_fd_sc_hd__tapvpwrvgnd_1
XTAP_534 VGND VPWR sky130_fd_sc_hd__tapvpwrvgnd_1
X_3263_ _0375_ _0376_ _0252_ _0251_ _1974_ VGND VGND VPWR VPWR _0377_ sky130_fd_sc_hd__a32o_1
XTAP_545 VGND VPWR sky130_fd_sc_hd__tapvpwrvgnd_1
XTAP_556 VGND VPWR sky130_fd_sc_hd__tapvpwrvgnd_1
XTAP_567 VGND VPWR sky130_fd_sc_hd__tapvpwrvgnd_1
X_2214_ net53 add_tmp\[25\] VGND VGND VPWR VPWR _1438_ sky130_fd_sc_hd__nor2_1
XTAP_578 VGND VPWR sky130_fd_sc_hd__tapvpwrvgnd_1
XTAP_589 VGND VPWR sky130_fd_sc_hd__tapvpwrvgnd_1
X_3194_ _0238_ _0307_ _0308_ VGND VGND VPWR VPWR _0309_ sky130_fd_sc_hd__nand3_4
X_2145_ _1005_ VGND VGND VPWR VPWR _1016_ sky130_fd_sc_hd__inv_2
XFILLER_0_72_41 VPWR VGND VPWR VGND sky130_ef_sc_hd__decap_12
Xclkbuf_3_5__f_clk clknet_0_clk VGND VGND VPWR VPWR clknet_3_5__leaf_clk sky130_fd_sc_hd__clkbuf_16
XFILLER_0_72_85 VPWR VGND VPWR VGND sky130_ef_sc_hd__decap_12
XFILLER_0_29_461 VGND VGND VPWR VPWR sky130_fd_sc_hd__fill_2
XFILLER_0_16_133 VGND VGND VPWR VPWR sky130_fd_sc_hd__fill_2
XFILLER_0_16_111 VGND VGND VPWR VPWR sky130_fd_sc_hd__decap_8
X_2978_ _2068_ _0094_ VGND VGND VPWR VPWR _0095_ sky130_fd_sc_hd__xnor2_2
XFILLER_0_16_144 VGND VGND VPWR VPWR sky130_fd_sc_hd__decap_8
XFILLER_0_71_261 VPWR VGND VPWR VGND sky130_ef_sc_hd__decap_12
XFILLER_0_31_147 VGND VGND VPWR VPWR sky130_fd_sc_hd__fill_2
XFILLER_0_31_169 VGND VGND VPWR VPWR sky130_fd_sc_hd__decap_4
XFILLER_0_39_225 VGND VGND VPWR VPWR sky130_fd_sc_hd__decap_6
XFILLER_0_77_19 VGND VGND VPWR VPWR sky130_fd_sc_hd__decap_8
XFILLER_0_10_309 VPWR VGND VPWR VGND sky130_ef_sc_hd__decap_12
X_3950_ _1061_ _1078_ VGND VGND VPWR VPWR _1079_ sky130_fd_sc_hd__xor2_1
X_2901_ _1825_ _1900_ _2075_ _1840_ VGND VGND VPWR VPWR _2076_ sky130_fd_sc_hd__a22o_1
X_3881_ _0952_ _0949_ VGND VGND VPWR VPWR _1004_ sky130_fd_sc_hd__nand2_1
XFILLER_0_42_66 VGND VGND VPWR VPWR sky130_fd_sc_hd__decap_6
X_2832_ _1759_ VGND VGND VPWR VPWR _2008_ sky130_fd_sc_hd__clkbuf_2
XFILLER_0_38_291 VGND VGND VPWR VPWR sky130_fd_sc_hd__fill_1
XFILLER_0_5_325 VGND VGND VPWR VPWR sky130_fd_sc_hd__fill_1
X_2763_ _1939_ VGND VGND VPWR VPWR _1940_ sky130_fd_sc_hd__buf_4
XFILLER_0_77_7 VPWR VGND VPWR VGND sky130_ef_sc_hd__decap_12
X_2694_ _1865_ _1869_ _1871_ VGND VGND VPWR VPWR _1872_ sky130_fd_sc_hd__nand3_1
XFILLER_0_13_169 VPWR VGND VPWR VGND sky130_ef_sc_hd__decap_12
XFILLER_0_6_66 VGND VGND VPWR VPWR sky130_fd_sc_hd__decap_4
XTAP_320 VGND VPWR sky130_fd_sc_hd__tapvpwrvgnd_1
XTAP_331 VGND VPWR sky130_fd_sc_hd__tapvpwrvgnd_1
XTAP_342 VGND VPWR sky130_fd_sc_hd__tapvpwrvgnd_1
X_4295_ clknet_3_1__leaf_clk _0040_ net35 VGND VGND VPWR VPWR add_tmp\[2\] sky130_fd_sc_hd__dfrtp_2
X_3315_ _0424_ _0425_ _0427_ VGND VGND VPWR VPWR _0428_ sky130_fd_sc_hd__nand3_2
XFILLER_0_67_74 VPWR VGND VPWR VGND sky130_ef_sc_hd__decap_12
XTAP_353 VGND VPWR sky130_fd_sc_hd__tapvpwrvgnd_1
XTAP_364 VGND VPWR sky130_fd_sc_hd__tapvpwrvgnd_1
XTAP_375 VGND VPWR sky130_fd_sc_hd__tapvpwrvgnd_1
X_3246_ _0356_ _0358_ net122 _0282_ VGND VGND VPWR VPWR _0360_ sky130_fd_sc_hd__a211o_1
XTAP_386 VGND VPWR sky130_fd_sc_hd__tapvpwrvgnd_1
XTAP_397 VGND VPWR sky130_fd_sc_hd__tapvpwrvgnd_1
XFILLER_0_20_3 VGND VGND VPWR VPWR sky130_fd_sc_hd__decap_3
X_3177_ _0289_ _0205_ _0211_ _0210_ _0291_ VGND VGND VPWR VPWR _0292_ sky130_fd_sc_hd__a32o_1
Xrebuffer11 _0141_ VGND VGND VPWR VPWR net84 sky130_fd_sc_hd__clkdlybuf4s15_2
X_2128_ _0821_ VGND VGND VPWR VPWR _0831_ sky130_fd_sc_hd__clkbuf_2
Xrebuffer33 _1966_ VGND VGND VPWR VPWR net106 sky130_fd_sc_hd__clkbuf_1
Xrebuffer44 _2046_ VGND VGND VPWR VPWR net117 sky130_fd_sc_hd__clkbuf_1
Xrebuffer55 _0131_ VGND VGND VPWR VPWR net128 sky130_fd_sc_hd__clkbuf_1
Xrebuffer22 _0306_ VGND VGND VPWR VPWR net95 sky130_fd_sc_hd__buf_1
XPHY_37 VGND VGND VPWR VPWR sky130_fd_sc_hd__decap_3
XPHY_26 VGND VGND VPWR VPWR sky130_fd_sc_hd__decap_3
XPHY_15 VGND VGND VPWR VPWR sky130_fd_sc_hd__decap_3
Xrebuffer66 _0144_ VGND VGND VPWR VPWR net152 sky130_fd_sc_hd__dlymetal6s2s_1
XPHY_48 VGND VGND VPWR VPWR sky130_fd_sc_hd__decap_3
XPHY_59 VGND VGND VPWR VPWR sky130_fd_sc_hd__decap_3
XFILLER_0_8_163 VPWR VGND VPWR VGND sky130_ef_sc_hd__decap_12
XFILLER_0_17_453 VGND VGND VPWR VPWR sky130_fd_sc_hd__fill_1
XFILLER_0_44_250 VGND VGND VPWR VPWR sky130_fd_sc_hd__fill_2
XFILLER_0_51_209 VGND VGND VPWR VPWR sky130_fd_sc_hd__decap_8
XFILLER_0_32_401 VGND VGND VPWR VPWR sky130_fd_sc_hd__fill_2
XFILLER_0_50_253 VPWR VGND VPWR VGND sky130_ef_sc_hd__decap_12
X_3100_ _0201_ _0202_ _0215_ VGND VGND VPWR VPWR _0216_ sky130_fd_sc_hd__a21oi_1
X_4080_ _1153_ _1155_ _1166_ VGND VGND VPWR VPWR _1220_ sky130_fd_sc_hd__a21o_1
X_3031_ _0074_ _0147_ VGND VGND VPWR VPWR _0148_ sky130_fd_sc_hd__xor2_1
XFILLER_0_77_139 VGND VGND VPWR VPWR sky130_fd_sc_hd__fill_1
X_3933_ _0997_ _1001_ VGND VGND VPWR VPWR _1061_ sky130_fd_sc_hd__nand2_1
X_3864_ _0981_ _0986_ VGND VGND VPWR VPWR _0987_ sky130_fd_sc_hd__xor2_1
XFILLER_0_5_111 VGND VGND VPWR VPWR sky130_fd_sc_hd__fill_1
XFILLER_0_33_209 VGND VGND VPWR VPWR sky130_fd_sc_hd__decap_6
X_2815_ add_tmp\[9\] _1990_ _1991_ VGND VGND VPWR VPWR _1992_ sky130_fd_sc_hd__mux2_1
X_3795_ _0870_ _0866_ _0865_ VGND VGND VPWR VPWR _0911_ sky130_fd_sc_hd__a21bo_1
XFILLER_0_5_166 VGND VGND VPWR VPWR sky130_fd_sc_hd__fill_2
XFILLER_0_41_220 VGND VGND VPWR VPWR sky130_fd_sc_hd__decap_4
X_2746_ _1863_ _1921_ _1922_ VGND VGND VPWR VPWR _1924_ sky130_fd_sc_hd__and3_1
X_2677_ _1794_ _1854_ _1852_ _1853_ VGND VGND VPWR VPWR _1856_ sky130_fd_sc_hd__o211ai_2
XFILLER_0_68_3 VPWR VGND VPWR VGND sky130_ef_sc_hd__decap_12
X_4278_ clknet_3_5__leaf_clk _0023_ net35 VGND VGND VPWR VPWR net49 sky130_fd_sc_hd__dfrtp_2
XTAP_161 VGND VPWR sky130_fd_sc_hd__tapvpwrvgnd_1
XTAP_172 VGND VPWR sky130_fd_sc_hd__tapvpwrvgnd_1
XTAP_183 VGND VPWR sky130_fd_sc_hd__tapvpwrvgnd_1
XTAP_194 VGND VPWR sky130_fd_sc_hd__tapvpwrvgnd_1
X_3229_ _1707_ _0342_ _0267_ _1686_ VGND VGND VPWR VPWR _0343_ sky130_fd_sc_hd__a22oi_4
XFILLER_0_9_461 VGND VGND VPWR VPWR sky130_fd_sc_hd__fill_2
XFILLER_0_64_334 VGND VGND VPWR VPWR sky130_fd_sc_hd__fill_1
XFILLER_0_32_253 VGND VGND VPWR VPWR sky130_fd_sc_hd__decap_4
XFILLER_0_23_57 VPWR VGND VPWR VGND sky130_ef_sc_hd__decap_12
XFILLER_0_15_209 VPWR VGND VPWR VGND sky130_ef_sc_hd__decap_12
X_2600_ _1777_ _1778_ _1779_ VGND VGND VPWR VPWR _1780_ sky130_fd_sc_hd__nand3_1
X_3580_ _0289_ net24 VGND VGND VPWR VPWR _0690_ sky130_fd_sc_hd__nand2_1
Xrebuffer2 _2005_ VGND VGND VPWR VPWR net75 sky130_fd_sc_hd__clkbuf_1
XFILLER_0_11_404 VGND VGND VPWR VPWR sky130_fd_sc_hd__fill_2
X_2531_ _1700_ _1702_ _1704_ VGND VGND VPWR VPWR _1713_ sky130_fd_sc_hd__or3_1
X_4201_ _1307_ _1349_ VGND VGND VPWR VPWR _1350_ sky130_fd_sc_hd__xnor2_1
X_2462_ _1649_ VGND VGND VPWR VPWR _0036_ sky130_fd_sc_hd__clkbuf_1
XFILLER_0_48_43 VGND VGND VPWR VPWR sky130_fd_sc_hd__fill_1
X_2393_ net49 _1580_ _1581_ net141 _1593_ VGND VGND VPWR VPWR _0023_ sky130_fd_sc_hd__a221o_1
X_4132_ _1274_ _1275_ _0321_ VGND VGND VPWR VPWR _1277_ sky130_fd_sc_hd__a21oi_1
X_4063_ _1199_ _1201_ VGND VGND VPWR VPWR _1202_ sky130_fd_sc_hd__nor2_1
X_3014_ _0127_ _0128_ _0129_ VGND VGND VPWR VPWR _0131_ sky130_fd_sc_hd__a21o_1
X_3916_ _0958_ _0990_ _1041_ _1042_ VGND VGND VPWR VPWR _1043_ sky130_fd_sc_hd__o211a_1
XFILLER_0_46_334 VPWR VGND VPWR VGND sky130_ef_sc_hd__decap_12
XFILLER_0_58_161 VGND VGND VPWR VPWR sky130_fd_sc_hd__decap_3
X_3847_ _0966_ _0967_ VGND VGND VPWR VPWR _0968_ sky130_fd_sc_hd__and2_1
XFILLER_0_73_164 VGND VGND VPWR VPWR sky130_fd_sc_hd__decap_4
X_3778_ _0887_ _0776_ _0891_ VGND VGND VPWR VPWR _0893_ sky130_fd_sc_hd__o21a_1
XFILLER_0_61_337 VGND VGND VPWR VPWR sky130_fd_sc_hd__decap_4
XFILLER_0_14_253 VGND VGND VPWR VPWR sky130_fd_sc_hd__decap_8
X_2729_ _1891_ _1906_ VGND VGND VPWR VPWR _1907_ sky130_fd_sc_hd__xnor2_2
XFILLER_0_1_191 VPWR VGND VPWR VGND sky130_ef_sc_hd__decap_12
XFILLER_0_49_161 VGND VGND VPWR VPWR sky130_fd_sc_hd__fill_1
XFILLER_0_64_131 VGND VGND VPWR VPWR sky130_fd_sc_hd__decap_3
XFILLER_0_64_164 VGND VGND VPWR VPWR sky130_fd_sc_hd__fill_1
XFILLER_0_64_197 VGND VGND VPWR VPWR sky130_fd_sc_hd__decap_6
XFILLER_0_60_381 VGND VGND VPWR VPWR sky130_fd_sc_hd__fill_1
X_3701_ _0742_ _0808_ VGND VGND VPWR VPWR _0810_ sky130_fd_sc_hd__or2_1
XFILLER_0_43_337 VGND VGND VPWR VPWR sky130_fd_sc_hd__decap_8
X_3632_ _0600_ _0676_ VGND VGND VPWR VPWR _0741_ sky130_fd_sc_hd__and2_1
X_3563_ _0204_ _0403_ VGND VGND VPWR VPWR _0673_ sky130_fd_sc_hd__nor2_1
XFILLER_0_70_189 VGND VGND VPWR VPWR sky130_fd_sc_hd__fill_2
X_2514_ net12 VGND VGND VPWR VPWR _1697_ sky130_fd_sc_hd__clkbuf_2
X_3494_ _0577_ _0599_ _0603_ VGND VGND VPWR VPWR _0605_ sky130_fd_sc_hd__o21a_1
X_2445_ _1492_ VGND VGND VPWR VPWR _1636_ sky130_fd_sc_hd__clkbuf_2
X_2376_ _1579_ VGND VGND VPWR VPWR _0020_ sky130_fd_sc_hd__clkbuf_1
X_4115_ _1131_ _1257_ _1188_ VGND VGND VPWR VPWR _1258_ sky130_fd_sc_hd__nor3_2
X_4046_ _1126_ VGND VGND VPWR VPWR _1183_ sky130_fd_sc_hd__clkbuf_2
XFILLER_0_66_418 VGND VGND VPWR VPWR sky130_fd_sc_hd__fill_2
XFILLER_0_19_345 VGND VGND VPWR VPWR sky130_fd_sc_hd__fill_1
XFILLER_0_19_389 VGND VGND VPWR VPWR sky130_fd_sc_hd__decap_3
XFILLER_0_69_223 VGND VGND VPWR VPWR sky130_fd_sc_hd__fill_1
XFILLER_0_69_278 VGND VGND VPWR VPWR sky130_fd_sc_hd__fill_2
XFILLER_0_37_153 VGND VGND VPWR VPWR sky130_fd_sc_hd__decap_6
XFILLER_0_20_25 VGND VGND VPWR VPWR sky130_fd_sc_hd__decap_3
XFILLER_0_4_209 VPWR VGND VPWR VGND sky130_ef_sc_hd__decap_12
XFILLER_0_25_337 VPWR VGND VPWR VGND sky130_ef_sc_hd__decap_12
XFILLER_0_20_36 VGND VGND VPWR VPWR sky130_fd_sc_hd__decap_8
XFILLER_0_40_329 VPWR VGND VPWR VGND sky130_ef_sc_hd__decap_12
XFILLER_0_0_415 VGND VGND VPWR VPWR sky130_fd_sc_hd__decap_4
XFILLER_0_29_12 VPWR VGND VPWR VGND sky130_ef_sc_hd__decap_12
XTAP_705 VGND VPWR sky130_fd_sc_hd__tapvpwrvgnd_1
XTAP_716 VGND VPWR sky130_fd_sc_hd__tapvpwrvgnd_1
X_2230_ _1444_ _1442_ VGND VGND VPWR VPWR _1454_ sky130_fd_sc_hd__or2b_1
XTAP_727 VGND VPWR sky130_fd_sc_hd__tapvpwrvgnd_1
XTAP_738 VGND VPWR sky130_fd_sc_hd__tapvpwrvgnd_1
XTAP_749 VGND VPWR sky130_fd_sc_hd__tapvpwrvgnd_1
X_2161_ _1092_ _1168_ _1179_ VGND VGND VPWR VPWR _1189_ sky130_fd_sc_hd__o21ai_2
XFILLER_0_45_11 VGND VGND VPWR VPWR sky130_fd_sc_hd__decap_3
XFILLER_0_17_9 VGND VGND VPWR VPWR sky130_fd_sc_hd__decap_3
XFILLER_0_45_77 VPWR VGND VPWR VGND sky130_ef_sc_hd__decap_12
XFILLER_0_75_204 VGND VGND VPWR VPWR sky130_fd_sc_hd__decap_4
XFILLER_0_75_237 VPWR VGND VPWR VGND sky130_ef_sc_hd__decap_12
XFILLER_0_0_57 VGND VGND VPWR VPWR sky130_fd_sc_hd__decap_8
X_2994_ net17 VGND VGND VPWR VPWR _0111_ sky130_fd_sc_hd__dlymetal6s2s_1
XFILLER_0_56_451 VPWR VGND VPWR VGND sky130_ef_sc_hd__decap_12
XFILLER_0_16_337 VPWR VGND VPWR VGND sky130_ef_sc_hd__decap_12
XFILLER_0_3_220 VGND VGND VPWR VPWR sky130_fd_sc_hd__decap_4
XFILLER_0_3_253 VGND VGND VPWR VPWR sky130_fd_sc_hd__fill_2
XFILLER_0_31_329 VGND VGND VPWR VPWR sky130_fd_sc_hd__fill_1
X_3615_ _0626_ _0654_ _0724_ VGND VGND VPWR VPWR _0725_ sky130_fd_sc_hd__a21oi_2
X_3546_ _0655_ _0656_ VGND VGND VPWR VPWR _0657_ sky130_fd_sc_hd__xor2_1
X_3477_ _0515_ _0587_ _0588_ VGND VGND VPWR VPWR _0589_ sky130_fd_sc_hd__or3_1
XFILLER_0_50_3 VGND VGND VPWR VPWR sky130_fd_sc_hd__decap_4
X_2428_ _1619_ _1621_ _1514_ add_tmp\[28\] VGND VGND VPWR VPWR _1622_ sky130_fd_sc_hd__a2bb2o_1
X_2359_ _1486_ _1565_ VGND VGND VPWR VPWR _1566_ sky130_fd_sc_hd__nor2_1
X_4029_ _1156_ _1164_ VGND VGND VPWR VPWR _1165_ sky130_fd_sc_hd__nand2_1
XFILLER_0_47_462 VGND VGND VPWR VPWR sky130_fd_sc_hd__fill_1
XFILLER_0_62_421 VPWR VGND VPWR VGND sky130_ef_sc_hd__decap_12
XFILLER_0_22_307 VGND VGND VPWR VPWR sky130_fd_sc_hd__fill_1
XFILLER_0_34_167 VGND VGND VPWR VPWR sky130_fd_sc_hd__decap_4
XFILLER_0_15_370 VPWR VGND VPWR VGND sky130_ef_sc_hd__decap_12
XFILLER_0_22_329 VGND VGND VPWR VPWR sky130_fd_sc_hd__fill_2
XFILLER_0_25_134 VGND VGND VPWR VPWR sky130_fd_sc_hd__decap_6
XFILLER_0_31_57 VGND VGND VPWR VPWR sky130_fd_sc_hd__decap_8
XFILLER_0_65_281 VPWR VGND VPWR VGND sky130_ef_sc_hd__decap_12
XFILLER_0_31_79 VGND VGND VPWR VPWR sky130_fd_sc_hd__fill_1
XFILLER_0_25_189 VGND VGND VPWR VPWR sky130_fd_sc_hd__decap_6
XFILLER_0_40_148 VGND VGND VPWR VPWR sky130_fd_sc_hd__fill_1
X_3400_ _0507_ _0512_ VGND VGND VPWR VPWR _0513_ sky130_fd_sc_hd__xor2_1
XFILLER_0_0_245 VGND VGND VPWR VPWR sky130_fd_sc_hd__decap_6
XFILLER_0_0_223 VGND VGND VPWR VPWR sky130_fd_sc_hd__fill_1
X_3331_ _0341_ _0343_ _0344_ VGND VGND VPWR VPWR _0444_ sky130_fd_sc_hd__o21bai_1
XTAP_502 VGND VPWR sky130_fd_sc_hd__tapvpwrvgnd_1
XTAP_513 VGND VPWR sky130_fd_sc_hd__tapvpwrvgnd_1
XTAP_524 VGND VPWR sky130_fd_sc_hd__tapvpwrvgnd_1
X_3262_ _0082_ VGND VGND VPWR VPWR _0376_ sky130_fd_sc_hd__buf_2
XTAP_535 VGND VPWR sky130_fd_sc_hd__tapvpwrvgnd_1
XTAP_546 VGND VPWR sky130_fd_sc_hd__tapvpwrvgnd_1
XTAP_557 VGND VPWR sky130_fd_sc_hd__tapvpwrvgnd_1
XTAP_568 VGND VPWR sky130_fd_sc_hd__tapvpwrvgnd_1
XTAP_579 VGND VPWR sky130_fd_sc_hd__tapvpwrvgnd_1
X_3193_ _0305_ _0306_ net97 net87 VGND VGND VPWR VPWR _0308_ sky130_fd_sc_hd__a211o_4
X_2213_ _1434_ _1425_ _1436_ _1423_ VGND VGND VPWR VPWR _1437_ sky130_fd_sc_hd__o211a_2
X_2144_ net37 add_tmp\[10\] VGND VGND VPWR VPWR _1005_ sky130_fd_sc_hd__nor2_1
XFILLER_0_72_53 VPWR VGND VPWR VGND sky130_ef_sc_hd__decap_12
XFILLER_0_72_97 VPWR VGND VPWR VGND sky130_ef_sc_hd__decap_12
XFILLER_0_44_421 VGND VGND VPWR VPWR sky130_fd_sc_hd__fill_1
X_2977_ _0076_ _0093_ VGND VGND VPWR VPWR _0094_ sky130_fd_sc_hd__xnor2_2
XFILLER_0_16_189 VGND VGND VPWR VPWR sky130_fd_sc_hd__decap_6
XFILLER_0_71_273 VGND VGND VPWR VPWR sky130_fd_sc_hd__decap_6
XFILLER_0_12_340 VPWR VGND VPWR VGND sky130_ef_sc_hd__decap_12
X_3529_ _1839_ _0192_ _0265_ _0331_ VGND VGND VPWR VPWR _0640_ sky130_fd_sc_hd__nand4_2
XFILLER_0_35_410 VGND VGND VPWR VPWR sky130_fd_sc_hd__decap_3
XFILLER_0_62_251 VGND VGND VPWR VPWR sky130_fd_sc_hd__fill_1
XFILLER_0_22_104 VGND VGND VPWR VPWR sky130_fd_sc_hd__decap_4
XFILLER_0_30_170 VGND VGND VPWR VPWR sky130_fd_sc_hd__fill_2
XFILLER_0_26_35 VPWR VGND VPWR VGND sky130_ef_sc_hd__decap_12
X_2900_ net32 VGND VGND VPWR VPWR _2075_ sky130_fd_sc_hd__clkbuf_2
X_3880_ _0876_ _1000_ _1001_ VGND VGND VPWR VPWR _1003_ sky130_fd_sc_hd__nand3_2
XFILLER_0_26_421 VPWR VGND VPWR VGND sky130_ef_sc_hd__decap_12
X_2831_ _2006_ VGND VGND VPWR VPWR _2007_ sky130_fd_sc_hd__clkbuf_2
XFILLER_0_5_337 VGND VGND VPWR VPWR sky130_fd_sc_hd__decap_8
X_2762_ net18 VGND VGND VPWR VPWR _1939_ sky130_fd_sc_hd__buf_4
XFILLER_0_53_262 VPWR VGND VPWR VGND sky130_ef_sc_hd__decap_12
X_2693_ _1725_ _1870_ _1827_ _1671_ VGND VGND VPWR VPWR _1871_ sky130_fd_sc_hd__a22o_1
XTAP_310 VGND VPWR sky130_fd_sc_hd__tapvpwrvgnd_1
XFILLER_0_6_78 VGND VGND VPWR VPWR sky130_fd_sc_hd__decap_6
XTAP_321 VGND VPWR sky130_fd_sc_hd__tapvpwrvgnd_1
XTAP_332 VGND VPWR sky130_fd_sc_hd__tapvpwrvgnd_1
XFILLER_0_21_192 VGND VGND VPWR VPWR sky130_fd_sc_hd__decap_4
X_4294_ clknet_3_1__leaf_clk _0039_ net35 VGND VGND VPWR VPWR add_tmp\[1\] sky130_fd_sc_hd__dfrtp_1
X_3314_ _1672_ _0335_ _0330_ _0426_ VGND VGND VPWR VPWR _0427_ sky130_fd_sc_hd__a31o_1
XFILLER_0_67_42 VPWR VGND VPWR VGND sky130_ef_sc_hd__decap_12
XTAP_343 VGND VPWR sky130_fd_sc_hd__tapvpwrvgnd_1
XTAP_354 VGND VPWR sky130_fd_sc_hd__tapvpwrvgnd_1
XTAP_365 VGND VPWR sky130_fd_sc_hd__tapvpwrvgnd_1
XTAP_376 VGND VPWR sky130_fd_sc_hd__tapvpwrvgnd_1
X_3245_ net122 _0282_ _0356_ _0358_ VGND VGND VPWR VPWR _0359_ sky130_fd_sc_hd__o211a_1
XFILLER_0_67_86 VGND VGND VPWR VPWR sky130_fd_sc_hd__decap_4
XTAP_387 VGND VPWR sky130_fd_sc_hd__tapvpwrvgnd_1
XTAP_398 VGND VPWR sky130_fd_sc_hd__tapvpwrvgnd_1
X_3176_ _0290_ VGND VGND VPWR VPWR _0291_ sky130_fd_sc_hd__clkbuf_2
Xrebuffer12 _0221_ VGND VGND VPWR VPWR net85 sky130_fd_sc_hd__buf_1
XFILLER_0_13_3 VGND VGND VPWR VPWR sky130_fd_sc_hd__fill_2
X_2127_ add_tmp\[31\] VGND VGND VPWR VPWR _0821_ sky130_fd_sc_hd__dlymetal6s2s_1
Xrebuffer34 _0194_ VGND VGND VPWR VPWR net107 sky130_fd_sc_hd__clkbuf_1
Xrebuffer45 _2084_ VGND VGND VPWR VPWR net118 sky130_fd_sc_hd__clkbuf_2
Xrebuffer23 _0128_ VGND VGND VPWR VPWR net96 sky130_fd_sc_hd__clkbuf_1
XPHY_38 VGND VGND VPWR VPWR sky130_fd_sc_hd__decap_3
XPHY_27 VGND VGND VPWR VPWR sky130_fd_sc_hd__decap_3
XPHY_16 VGND VGND VPWR VPWR sky130_fd_sc_hd__decap_3
Xrebuffer67 _2087_ VGND VGND VPWR VPWR net153 sky130_fd_sc_hd__dlymetal6s2s_1
Xrebuffer56 _0258_ VGND VGND VPWR VPWR net137 sky130_fd_sc_hd__dlygate4sd1_1
XPHY_49 VGND VGND VPWR VPWR sky130_fd_sc_hd__decap_3
XFILLER_0_29_281 VPWR VGND VPWR VGND sky130_ef_sc_hd__decap_12
XFILLER_0_8_197 VPWR VGND VPWR VGND sky130_ef_sc_hd__decap_12
XFILLER_0_8_175 VPWR VGND VPWR VGND sky130_ef_sc_hd__decap_12
XFILLER_0_12_37 VPWR VGND VPWR VGND sky130_ef_sc_hd__decap_12
XFILLER_0_2_307 VGND VGND VPWR VPWR sky130_fd_sc_hd__fill_1
XFILLER_0_50_265 VGND VGND VPWR VPWR sky130_fd_sc_hd__decap_3
Xoutput70 net70 VGND VGND VPWR VPWR out_acc[8] sky130_fd_sc_hd__clkbuf_4
X_3030_ _0145_ _0146_ VGND VGND VPWR VPWR _0147_ sky130_fd_sc_hd__or2_4
XFILLER_0_18_207 VGND VGND VPWR VPWR sky130_fd_sc_hd__fill_1
X_3932_ _1014_ _1023_ VGND VGND VPWR VPWR _1060_ sky130_fd_sc_hd__nand2_1
XFILLER_0_58_365 VPWR VGND VPWR VGND sky130_ef_sc_hd__decap_12
X_3863_ _0823_ _0982_ _0985_ VGND VGND VPWR VPWR _0986_ sky130_fd_sc_hd__o21a_1
XFILLER_0_73_335 VGND VGND VPWR VPWR sky130_fd_sc_hd__fill_1
X_2814_ _1489_ VGND VGND VPWR VPWR _1991_ sky130_fd_sc_hd__clkbuf_2
XFILLER_0_26_251 VGND VGND VPWR VPWR sky130_fd_sc_hd__fill_1
X_3794_ _0910_ VGND VGND VPWR VPWR _0059_ sky130_fd_sc_hd__clkbuf_1
XFILLER_0_14_424 VPWR VGND VPWR VGND sky130_ef_sc_hd__decap_12
X_2745_ _1921_ _1922_ _1863_ VGND VGND VPWR VPWR _1923_ sky130_fd_sc_hd__a21oi_1
X_2676_ _1852_ _1853_ _1794_ _1854_ VGND VGND VPWR VPWR _1855_ sky130_fd_sc_hd__a211o_1
XFILLER_0_41_243 VGND VGND VPWR VPWR sky130_fd_sc_hd__fill_1
XTAP_162 VGND VPWR sky130_fd_sc_hd__tapvpwrvgnd_1
XTAP_173 VGND VPWR sky130_fd_sc_hd__tapvpwrvgnd_1
XTAP_184 VGND VPWR sky130_fd_sc_hd__tapvpwrvgnd_1
X_4277_ clknet_3_4__leaf_clk _0022_ net35 VGND VGND VPWR VPWR net48 sky130_fd_sc_hd__dfrtp_4
XTAP_195 VGND VPWR sky130_fd_sc_hd__tapvpwrvgnd_1
X_3228_ _0120_ VGND VGND VPWR VPWR _0342_ sky130_fd_sc_hd__buf_2
X_3159_ _0185_ _0182_ _0184_ VGND VGND VPWR VPWR _0274_ sky130_fd_sc_hd__a21bo_1
XFILLER_0_49_332 VGND VGND VPWR VPWR sky130_fd_sc_hd__decap_4
XFILLER_0_9_440 VGND VGND VPWR VPWR sky130_fd_sc_hd__decap_8
XFILLER_0_32_243 VGND VGND VPWR VPWR sky130_fd_sc_hd__decap_8
XFILLER_0_2_3 VPWR VGND VPWR VGND sky130_ef_sc_hd__decap_12
XFILLER_0_23_69 VGND VGND VPWR VPWR sky130_fd_sc_hd__decap_8
XFILLER_0_55_379 VGND VGND VPWR VPWR sky130_fd_sc_hd__fill_1
XFILLER_0_70_305 VGND VGND VPWR VPWR sky130_fd_sc_hd__decap_3
Xrebuffer3 _0138_ VGND VGND VPWR VPWR net76 sky130_fd_sc_hd__dlygate4sd2_1
XFILLER_0_70_349 VGND VGND VPWR VPWR sky130_fd_sc_hd__decap_8
X_2530_ _1710_ _1711_ add_tmp\[3\] _1712_ VGND VGND VPWR VPWR _0041_ sky130_fd_sc_hd__a2bb2o_1
XFILLER_0_11_449 VPWR VGND VPWR VGND sky130_ef_sc_hd__decap_12
X_2461_ net63 _1648_ _1636_ VGND VGND VPWR VPWR _1649_ sky130_fd_sc_hd__mux2_1
X_4200_ _1345_ _1348_ VGND VGND VPWR VPWR _1349_ sky130_fd_sc_hd__xnor2_1
XFILLER_0_48_11 VGND VGND VPWR VPWR sky130_fd_sc_hd__decap_3
X_2392_ _1591_ _1592_ _1508_ VGND VGND VPWR VPWR _1593_ sky130_fd_sc_hd__o21a_1
X_4131_ _1226_ _1229_ _1273_ VGND VGND VPWR VPWR _1275_ sky130_fd_sc_hd__o21ai_1
XFILLER_0_48_99 VPWR VGND VPWR VGND sky130_ef_sc_hd__decap_12
X_4062_ _1130_ _1198_ VGND VGND VPWR VPWR _1201_ sky130_fd_sc_hd__nor2_1
XFILLER_0_3_57 VPWR VGND VPWR VGND sky130_ef_sc_hd__decap_12
X_3013_ _0127_ net96 _0129_ VGND VGND VPWR VPWR _0130_ sky130_fd_sc_hd__nand3_4
XFILLER_0_64_54 VGND VGND VPWR VPWR sky130_fd_sc_hd__fill_1
X_3915_ _1040_ _1031_ _1032_ VGND VGND VPWR VPWR _1042_ sky130_fd_sc_hd__or3_4
XFILLER_0_46_313 VGND VGND VPWR VPWR sky130_fd_sc_hd__fill_1
XFILLER_0_58_173 VPWR VGND VPWR VGND sky130_ef_sc_hd__decap_12
XFILLER_0_46_346 VGND VGND VPWR VPWR sky130_fd_sc_hd__fill_1
XFILLER_0_58_195 VGND VGND VPWR VPWR sky130_fd_sc_hd__fill_1
XFILLER_0_73_121 VPWR VGND VPWR VGND sky130_ef_sc_hd__decap_12
X_3846_ _0960_ _0854_ _0965_ VGND VGND VPWR VPWR _0967_ sky130_fd_sc_hd__o21ai_2
XFILLER_0_6_421 VPWR VGND VPWR VGND sky130_ef_sc_hd__decap_12
X_3777_ _0887_ _0776_ _0891_ VGND VGND VPWR VPWR _0892_ sky130_fd_sc_hd__nor3_1
XFILLER_0_14_243 VGND VGND VPWR VPWR sky130_fd_sc_hd__decap_8
X_2728_ _1893_ _1905_ VGND VGND VPWR VPWR _1906_ sky130_fd_sc_hd__xnor2_2
X_2659_ _1679_ _1837_ VGND VGND VPWR VPWR _1838_ sky130_fd_sc_hd__nand2_1
XFILLER_0_1_181 VGND VGND VPWR VPWR sky130_fd_sc_hd__decap_4
XFILLER_0_69_449 VGND VGND VPWR VPWR sky130_fd_sc_hd__decap_8
XFILLER_0_49_184 VGND VGND VPWR VPWR sky130_fd_sc_hd__fill_1
XFILLER_0_9_281 VPWR VGND VPWR VGND sky130_ef_sc_hd__decap_12
XFILLER_0_37_368 VGND VGND VPWR VPWR sky130_fd_sc_hd__fill_2
XFILLER_0_18_47 VPWR VGND VPWR VGND sky130_ef_sc_hd__decap_12
XFILLER_0_28_335 VGND VGND VPWR VPWR sky130_fd_sc_hd__fill_2
XFILLER_0_55_121 VGND VGND VPWR VPWR sky130_fd_sc_hd__fill_1
X_3700_ _0742_ _0808_ VGND VGND VPWR VPWR _0809_ sky130_fd_sc_hd__nand2_1
XFILLER_0_55_176 VPWR VGND VPWR VGND sky130_ef_sc_hd__decap_12
X_3631_ _0740_ VGND VGND VPWR VPWR _0057_ sky130_fd_sc_hd__clkbuf_1
X_3562_ _0204_ _0517_ _0617_ VGND VGND VPWR VPWR _0672_ sky130_fd_sc_hd__and3b_1
X_2513_ _1693_ _1678_ _1694_ _1695_ VGND VGND VPWR VPWR _1696_ sky130_fd_sc_hd__a22o_1
XFILLER_0_59_65 VGND VGND VPWR VPWR sky130_fd_sc_hd__fill_1
XFILLER_0_59_76 VGND VGND VPWR VPWR sky130_fd_sc_hd__decap_3
X_3493_ _0577_ _0599_ _0603_ VGND VGND VPWR VPWR _0604_ sky130_fd_sc_hd__nor3_1
X_2444_ _1632_ _1633_ _1634_ VGND VGND VPWR VPWR _1635_ sky130_fd_sc_hd__o21ai_1
X_2375_ net45 _1578_ _1553_ VGND VGND VPWR VPWR _1579_ sky130_fd_sc_hd__mux2_1
X_4114_ _0747_ VGND VGND VPWR VPWR _1257_ sky130_fd_sc_hd__clkbuf_2
X_4045_ _1117_ _1181_ VGND VGND VPWR VPWR _1182_ sky130_fd_sc_hd__or2_1
X_3829_ _0946_ _0947_ _0876_ VGND VGND VPWR VPWR _0948_ sky130_fd_sc_hd__a21o_1
XFILLER_0_27_390 VGND VGND VPWR VPWR sky130_fd_sc_hd__fill_2
XFILLER_0_61_113 VGND VGND VPWR VPWR sky130_fd_sc_hd__decap_4
XFILLER_0_42_393 VPWR VGND VPWR VGND sky130_ef_sc_hd__decap_12
XFILLER_0_69_202 VGND VGND VPWR VPWR sky130_fd_sc_hd__fill_1
XFILLER_0_37_121 VGND VGND VPWR VPWR sky130_fd_sc_hd__decap_3
XFILLER_0_25_316 VGND VGND VPWR VPWR sky130_fd_sc_hd__decap_8
XFILLER_0_25_349 VPWR VGND VPWR VGND sky130_ef_sc_hd__decap_12
XFILLER_0_20_59 VGND VGND VPWR VPWR sky130_fd_sc_hd__decap_6
XFILLER_0_0_405 VGND VGND VPWR VPWR sky130_fd_sc_hd__decap_4
XFILLER_0_33_393 VGND VGND VPWR VPWR sky130_fd_sc_hd__decap_8
XFILLER_0_0_449 VGND VGND VPWR VPWR sky130_fd_sc_hd__decap_4
XFILLER_0_29_24 VPWR VGND VPWR VGND sky130_ef_sc_hd__decap_12
XTAP_706 VGND VPWR sky130_fd_sc_hd__tapvpwrvgnd_1
XTAP_717 VGND VPWR sky130_fd_sc_hd__tapvpwrvgnd_1
XTAP_728 VGND VPWR sky130_fd_sc_hd__tapvpwrvgnd_1
XTAP_739 VGND VPWR sky130_fd_sc_hd__tapvpwrvgnd_1
X_2160_ net65 add_tmp\[3\] VGND VGND VPWR VPWR _1179_ sky130_fd_sc_hd__nand2_1
XFILLER_0_45_89 VGND VGND VPWR VPWR sky130_fd_sc_hd__decap_6
XFILLER_0_75_249 VGND VGND VPWR VPWR sky130_fd_sc_hd__decap_8
X_2993_ _1839_ _1841_ _1938_ _1942_ VGND VGND VPWR VPWR _0110_ sky130_fd_sc_hd__and4_1
XFILLER_0_61_44 VPWR VGND VPWR VGND sky130_ef_sc_hd__decap_12
XFILLER_0_16_316 VGND VGND VPWR VPWR sky130_fd_sc_hd__fill_1
XFILLER_0_16_349 VPWR VGND VPWR VGND sky130_ef_sc_hd__decap_12
XFILLER_0_43_113 VGND VGND VPWR VPWR sky130_fd_sc_hd__decap_8
XFILLER_0_43_135 VPWR VGND VPWR VGND sky130_ef_sc_hd__decap_12
X_3614_ _0652_ _0653_ VGND VGND VPWR VPWR _0724_ sky130_fd_sc_hd__and2b_1
XFILLER_0_9_89 VGND VGND VPWR VPWR sky130_fd_sc_hd__fill_1
X_3545_ _0580_ _0558_ _0557_ VGND VGND VPWR VPWR _0656_ sky130_fd_sc_hd__a21bo_1
X_3476_ _0585_ _0586_ _0488_ _0500_ VGND VGND VPWR VPWR _0588_ sky130_fd_sc_hd__o211a_1
X_2427_ _1487_ _1620_ VGND VGND VPWR VPWR _1621_ sky130_fd_sc_hd__or2b_1
XFILLER_0_43_3 VPWR VGND VPWR VGND sky130_ef_sc_hd__decap_12
X_2358_ _1563_ _1564_ VGND VGND VPWR VPWR _1565_ sky130_fd_sc_hd__xnor2_1
X_2289_ _1506_ _1507_ _1508_ VGND VGND VPWR VPWR _1509_ sky130_fd_sc_hd__o21a_1
X_4028_ _1096_ _1163_ VGND VGND VPWR VPWR _1164_ sky130_fd_sc_hd__xnor2_1
XFILLER_0_19_187 VGND VGND VPWR VPWR sky130_fd_sc_hd__decap_3
XFILLER_0_62_433 VPWR VGND VPWR VGND sky130_ef_sc_hd__decap_12
XFILLER_0_57_205 VPWR VGND VPWR VGND sky130_ef_sc_hd__decap_12
XFILLER_0_65_293 VPWR VGND VPWR VGND sky130_ef_sc_hd__decap_12
XFILLER_0_33_190 VGND VGND VPWR VPWR sky130_fd_sc_hd__fill_1
X_3330_ _0355_ _0358_ VGND VGND VPWR VPWR _0443_ sky130_fd_sc_hd__nand2_1
XFILLER_0_0_279 VGND VGND VPWR VPWR sky130_fd_sc_hd__fill_1
XFILLER_0_21_385 VGND VGND VPWR VPWR sky130_fd_sc_hd__decap_6
XTAP_503 VGND VPWR sky130_fd_sc_hd__tapvpwrvgnd_1
XTAP_514 VGND VPWR sky130_fd_sc_hd__tapvpwrvgnd_1
XTAP_525 VGND VPWR sky130_fd_sc_hd__tapvpwrvgnd_1
X_3261_ _1955_ VGND VGND VPWR VPWR _0375_ sky130_fd_sc_hd__dlymetal6s2s_1
XTAP_536 VGND VPWR sky130_fd_sc_hd__tapvpwrvgnd_1
XTAP_547 VGND VPWR sky130_fd_sc_hd__tapvpwrvgnd_1
XTAP_558 VGND VPWR sky130_fd_sc_hd__tapvpwrvgnd_1
XTAP_569 VGND VPWR sky130_fd_sc_hd__tapvpwrvgnd_1
X_3192_ net97 net88 _0305_ net95 VGND VGND VPWR VPWR _0307_ sky130_fd_sc_hd__o211ai_4
X_2212_ _1430_ _1421_ _1435_ _1420_ VGND VGND VPWR VPWR _1436_ sky130_fd_sc_hd__a211o_1
X_2143_ net38 add_tmp\[11\] VGND VGND VPWR VPWR _0994_ sky130_fd_sc_hd__nor2_1
XFILLER_0_48_205 VGND VGND VPWR VPWR sky130_fd_sc_hd__decap_8
XFILLER_0_72_65 VGND VGND VPWR VPWR sky130_fd_sc_hd__decap_4
XFILLER_0_63_219 VGND VGND VPWR VPWR sky130_fd_sc_hd__decap_4
XFILLER_0_8_379 VGND VGND VPWR VPWR sky130_fd_sc_hd__decap_8
X_2976_ _0081_ _0092_ VGND VGND VPWR VPWR _0093_ sky130_fd_sc_hd__xnor2_2
XFILLER_0_12_352 VPWR VGND VPWR VGND sky130_ef_sc_hd__decap_12
X_3528_ _1783_ _0265_ _0331_ _1706_ VGND VGND VPWR VPWR _0639_ sky130_fd_sc_hd__a22o_1
X_3459_ _0203_ _2006_ _0078_ _0158_ VGND VGND VPWR VPWR _0571_ sky130_fd_sc_hd__and4_1
XFILLER_0_39_249 VGND VGND VPWR VPWR sky130_fd_sc_hd__fill_1
XFILLER_0_47_293 VGND VGND VPWR VPWR sky130_fd_sc_hd__decap_8
XFILLER_0_30_182 VGND VGND VPWR VPWR sky130_fd_sc_hd__fill_1
XFILLER_0_30_193 VGND VGND VPWR VPWR sky130_fd_sc_hd__decap_3
Xhold70 add_tmp\[0\] VGND VGND VPWR VPWR net143 sky130_fd_sc_hd__dlygate4sd3_1
XFILLER_0_26_25 VGND VGND VPWR VPWR sky130_fd_sc_hd__decap_3
XFILLER_0_26_47 VGND VGND VPWR VPWR sky130_fd_sc_hd__decap_8
XFILLER_0_42_35 VGND VGND VPWR VPWR sky130_fd_sc_hd__fill_1
X_2830_ _1744_ VGND VGND VPWR VPWR _2006_ sky130_fd_sc_hd__clkbuf_2
XFILLER_0_5_305 VPWR VGND VPWR VGND sky130_ef_sc_hd__decap_12
XFILLER_0_26_433 VGND VGND VPWR VPWR sky130_fd_sc_hd__fill_2
X_2761_ net17 VGND VGND VPWR VPWR _1938_ sky130_fd_sc_hd__clkbuf_2
XFILLER_0_13_105 VGND VGND VPWR VPWR sky130_fd_sc_hd__fill_1
X_2692_ net17 VGND VGND VPWR VPWR _1870_ sky130_fd_sc_hd__buf_4
XFILLER_0_53_274 VGND VGND VPWR VPWR sky130_fd_sc_hd__decap_6
XTAP_311 VGND VPWR sky130_fd_sc_hd__tapvpwrvgnd_1
XTAP_300 VGND VPWR sky130_fd_sc_hd__tapvpwrvgnd_1
XTAP_322 VGND VPWR sky130_fd_sc_hd__tapvpwrvgnd_1
XTAP_333 VGND VPWR sky130_fd_sc_hd__tapvpwrvgnd_1
X_4293_ clknet_3_1__leaf_clk _0038_ net35 VGND VGND VPWR VPWR add_tmp\[0\] sky130_fd_sc_hd__dfrtp_1
X_3313_ _1658_ _0332_ net25 VGND VGND VPWR VPWR _0426_ sky130_fd_sc_hd__and3_1
XFILLER_0_67_54 VGND VGND VPWR VPWR sky130_fd_sc_hd__fill_2
XTAP_344 VGND VPWR sky130_fd_sc_hd__tapvpwrvgnd_1
XTAP_355 VGND VPWR sky130_fd_sc_hd__tapvpwrvgnd_1
XTAP_366 VGND VPWR sky130_fd_sc_hd__tapvpwrvgnd_1
X_3244_ _0357_ _1818_ _0353_ _0355_ VGND VGND VPWR VPWR _0358_ sky130_fd_sc_hd__nand4_2
XTAP_377 VGND VPWR sky130_fd_sc_hd__tapvpwrvgnd_1
XTAP_388 VGND VPWR sky130_fd_sc_hd__tapvpwrvgnd_1
XTAP_399 VGND VPWR sky130_fd_sc_hd__tapvpwrvgnd_1
X_3175_ _0107_ VGND VGND VPWR VPWR _0290_ sky130_fd_sc_hd__clkbuf_2
Xrebuffer46 _0143_ VGND VGND VPWR VPWR net119 sky130_fd_sc_hd__clkbuf_1
Xrebuffer35 net144 VGND VGND VPWR VPWR net108 sky130_fd_sc_hd__clkbuf_1
Xrebuffer13 net85 VGND VGND VPWR VPWR net86 sky130_fd_sc_hd__clkbuf_1
Xrebuffer24 _0218_ VGND VGND VPWR VPWR net97 sky130_fd_sc_hd__dlygate4sd1_1
XPHY_28 VGND VGND VPWR VPWR sky130_fd_sc_hd__decap_3
XPHY_17 VGND VGND VPWR VPWR sky130_fd_sc_hd__decap_3
Xrebuffer57 net137 VGND VGND VPWR VPWR net142 sky130_fd_sc_hd__dlygate4sd1_1
XPHY_39 VGND VGND VPWR VPWR sky130_fd_sc_hd__decap_3
XFILLER_0_8_110 VGND VGND VPWR VPWR sky130_fd_sc_hd__decap_8
XFILLER_0_8_187 VGND VGND VPWR VPWR sky130_fd_sc_hd__fill_2
XFILLER_0_29_293 VPWR VGND VPWR VGND sky130_ef_sc_hd__decap_12
X_2959_ _2073_ _2083_ _2081_ VGND VGND VPWR VPWR _0076_ sky130_fd_sc_hd__a21oi_1
XFILLER_0_32_436 VGND VGND VPWR VPWR sky130_fd_sc_hd__decap_4
XFILLER_0_12_49 VPWR VGND VPWR VGND sky130_ef_sc_hd__decap_12
XFILLER_0_35_252 VPWR VGND VPWR VGND sky130_ef_sc_hd__decap_12
Xoutput60 net60 VGND VGND VPWR VPWR out_acc[31] sky130_fd_sc_hd__clkbuf_4
Xoutput71 net71 VGND VGND VPWR VPWR out_acc[9] sky130_fd_sc_hd__clkbuf_4
XFILLER_0_37_24 VGND VGND VPWR VPWR sky130_fd_sc_hd__fill_2
XFILLER_0_37_57 VGND VGND VPWR VPWR sky130_fd_sc_hd__decap_4
XFILLER_0_77_119 VGND VGND VPWR VPWR sky130_fd_sc_hd__decap_8
XFILLER_0_53_23 VPWR VGND VPWR VGND sky130_ef_sc_hd__decap_12
X_3931_ _1002_ _1003_ _1004_ VGND VGND VPWR VPWR _1058_ sky130_fd_sc_hd__nand3_1
XFILLER_0_58_377 VPWR VGND VPWR VGND sky130_ef_sc_hd__decap_12
X_3862_ _0816_ _0983_ _0905_ VGND VGND VPWR VPWR _0985_ sky130_fd_sc_hd__a21o_1
X_2813_ _1921_ _1986_ _1989_ VGND VGND VPWR VPWR _1990_ sky130_fd_sc_hd__a21oi_1
XFILLER_0_5_113 VPWR VGND VPWR VGND sky130_ef_sc_hd__decap_12
X_3793_ add_tmp\[21\] _0909_ _0596_ VGND VGND VPWR VPWR _0910_ sky130_fd_sc_hd__mux2_1
XFILLER_0_14_436 VPWR VGND VPWR VGND sky130_ef_sc_hd__decap_12
XFILLER_0_5_179 VGND VGND VPWR VPWR sky130_fd_sc_hd__fill_1
XFILLER_0_5_157 VGND VGND VPWR VPWR sky130_fd_sc_hd__fill_2
X_2744_ _1808_ _1860_ _1919_ _1920_ VGND VGND VPWR VPWR _1922_ sky130_fd_sc_hd__a22o_1
X_2675_ _1803_ _1793_ _1795_ VGND VGND VPWR VPWR _1854_ sky130_fd_sc_hd__nor3_2
XFILLER_0_1_341 VGND VGND VPWR VPWR sky130_fd_sc_hd__fill_1
XFILLER_0_1_363 VGND VGND VPWR VPWR sky130_fd_sc_hd__decap_6
X_4276_ clknet_3_5__leaf_clk _0021_ net35 VGND VGND VPWR VPWR net46 sky130_fd_sc_hd__dfrtp_4
XTAP_163 VGND VPWR sky130_fd_sc_hd__tapvpwrvgnd_1
XTAP_174 VGND VPWR sky130_fd_sc_hd__tapvpwrvgnd_1
XTAP_185 VGND VPWR sky130_fd_sc_hd__tapvpwrvgnd_1
XTAP_196 VGND VPWR sky130_fd_sc_hd__tapvpwrvgnd_1
X_3227_ _1716_ _0340_ VGND VGND VPWR VPWR _0341_ sky130_fd_sc_hd__nand2_1
X_3158_ _0271_ _0266_ _0269_ VGND VGND VPWR VPWR _0273_ sky130_fd_sc_hd__nand3_1
X_3089_ _1895_ VGND VGND VPWR VPWR _0205_ sky130_fd_sc_hd__clkbuf_2
XFILLER_0_32_222 VGND VGND VPWR VPWR sky130_fd_sc_hd__decap_6
XFILLER_0_32_233 VGND VGND VPWR VPWR sky130_fd_sc_hd__decap_3
XFILLER_0_72_380 VGND VGND VPWR VPWR sky130_fd_sc_hd__decap_8
XFILLER_0_32_266 VGND VGND VPWR VPWR sky130_fd_sc_hd__fill_2
XFILLER_0_23_222 VGND VGND VPWR VPWR sky130_fd_sc_hd__fill_2
Xrebuffer4 net119 VGND VGND VPWR VPWR net77 sky130_fd_sc_hd__clkbuf_2
X_2460_ _1488_ _1482_ _1647_ _1634_ VGND VGND VPWR VPWR _1648_ sky130_fd_sc_hd__o31ai_1
X_4130_ _1226_ _1229_ _1273_ VGND VGND VPWR VPWR _1274_ sky130_fd_sc_hd__or3_1
X_2391_ _1430_ _1590_ _1422_ VGND VGND VPWR VPWR _1592_ sky130_fd_sc_hd__and3_1
X_4061_ _1130_ _1198_ VGND VGND VPWR VPWR _1199_ sky130_fd_sc_hd__and2_1
XFILLER_0_3_69 VGND VGND VPWR VPWR sky130_fd_sc_hd__fill_1
X_3012_ _2090_ _2102_ _2101_ VGND VGND VPWR VPWR _0129_ sky130_fd_sc_hd__a21bo_1
XFILLER_0_58_141 VPWR VGND VPWR VGND sky130_ef_sc_hd__decap_12
X_3914_ _1031_ _1032_ _1040_ VGND VGND VPWR VPWR _1041_ sky130_fd_sc_hd__o21ai_1
XFILLER_0_73_133 VPWR VGND VPWR VGND sky130_ef_sc_hd__decap_12
X_3845_ _0960_ _0854_ _0965_ VGND VGND VPWR VPWR _0966_ sky130_fd_sc_hd__or3_1
XFILLER_0_6_433 VPWR VGND VPWR VGND sky130_ef_sc_hd__decap_12
X_3776_ _0888_ _0890_ VGND VGND VPWR VPWR _0891_ sky130_fd_sc_hd__nor2_1
X_2727_ _1902_ _1904_ VGND VGND VPWR VPWR _1905_ sky130_fd_sc_hd__nor2_4
XFILLER_0_73_3 VPWR VGND VPWR VGND sky130_ef_sc_hd__decap_12
X_2658_ net30 VGND VGND VPWR VPWR _1837_ sky130_fd_sc_hd__buf_2
XFILLER_0_10_461 VGND VGND VPWR VPWR sky130_fd_sc_hd__fill_2
X_2589_ _1768_ _1769_ _1741_ VGND VGND VPWR VPWR _1770_ sky130_fd_sc_hd__mux2_1
X_4259_ clknet_3_3__leaf_clk _0004_ net35 VGND VGND VPWR VPWR net58 sky130_fd_sc_hd__dfrtp_4
XFILLER_0_69_406 VPWR VGND VPWR VGND sky130_ef_sc_hd__decap_12
XFILLER_0_9_293 VGND VGND VPWR VPWR sky130_fd_sc_hd__fill_1
XFILLER_0_18_59 VGND VGND VPWR VPWR sky130_fd_sc_hd__decap_6
XFILLER_0_55_155 VPWR VGND VPWR VGND sky130_ef_sc_hd__decap_12
X_3630_ add_tmp\[19\] _0739_ _0596_ VGND VGND VPWR VPWR _0740_ sky130_fd_sc_hd__mux2_1
XFILLER_0_43_328 VGND VGND VPWR VPWR sky130_fd_sc_hd__fill_1
XFILLER_0_55_188 VGND VGND VPWR VPWR sky130_fd_sc_hd__decap_8
XFILLER_0_70_114 VGND VGND VPWR VPWR sky130_fd_sc_hd__fill_1
XFILLER_0_70_125 VGND VGND VPWR VPWR sky130_fd_sc_hd__decap_8
X_3561_ _0608_ _0624_ _0623_ VGND VGND VPWR VPWR _0671_ sky130_fd_sc_hd__a21bo_1
XFILLER_0_3_447 VGND VGND VPWR VPWR sky130_fd_sc_hd__fill_1
X_2512_ net19 VGND VGND VPWR VPWR _1695_ sky130_fd_sc_hd__buf_6
XFILLER_0_59_11 VGND VGND VPWR VPWR sky130_fd_sc_hd__fill_1
XFILLER_0_11_225 VGND VGND VPWR VPWR sky130_fd_sc_hd__decap_4
X_3492_ _0600_ _0602_ VGND VGND VPWR VPWR _0603_ sky130_fd_sc_hd__nor2_1
X_2443_ _1514_ _0831_ VGND VGND VPWR VPWR _1634_ sky130_fd_sc_hd__nand2_2
X_2374_ _1576_ add_tmp\[18\] _1577_ VGND VGND VPWR VPWR _1578_ sky130_fd_sc_hd__mux2_1
X_4113_ _1186_ _1202_ _1199_ VGND VGND VPWR VPWR _1256_ sky130_fd_sc_hd__a21oi_2
X_4044_ _1113_ _1176_ VGND VGND VPWR VPWR _1181_ sky130_fd_sc_hd__or2_1
XFILLER_0_19_369 VPWR VGND VPWR VGND sky130_ef_sc_hd__decap_12
XFILLER_0_46_166 VGND VGND VPWR VPWR sky130_fd_sc_hd__fill_2
X_3828_ _0945_ _0943_ _0944_ VGND VGND VPWR VPWR _0947_ sky130_fd_sc_hd__nand3_2
X_3759_ _0870_ _0865_ _0866_ VGND VGND VPWR VPWR _0872_ sky130_fd_sc_hd__nand3_1
XFILLER_0_42_361 VGND VGND VPWR VPWR sky130_fd_sc_hd__decap_3
XFILLER_0_69_225 VGND VGND VPWR VPWR sky130_fd_sc_hd__decap_8
XFILLER_0_40_309 VGND VGND VPWR VPWR sky130_fd_sc_hd__decap_6
XTAP_707 VGND VPWR sky130_fd_sc_hd__tapvpwrvgnd_1
XFILLER_0_29_36 VGND VGND VPWR VPWR sky130_fd_sc_hd__fill_2
XTAP_718 VGND VPWR sky130_fd_sc_hd__tapvpwrvgnd_1
XTAP_729 VGND VPWR sky130_fd_sc_hd__tapvpwrvgnd_1
XFILLER_0_45_57 VPWR VGND VPWR VGND sky130_ef_sc_hd__decap_12
XFILLER_0_0_37 VGND VGND VPWR VPWR sky130_fd_sc_hd__fill_1
XFILLER_0_28_100 VPWR VGND VPWR VGND sky130_ef_sc_hd__decap_12
X_2992_ _1892_ _0108_ VGND VGND VPWR VPWR _0109_ sky130_fd_sc_hd__nand2_2
XFILLER_0_16_306 VGND VGND VPWR VPWR sky130_fd_sc_hd__fill_2
XFILLER_0_43_147 VGND VGND VPWR VPWR sky130_fd_sc_hd__decap_4
X_3613_ _0697_ _0722_ VGND VGND VPWR VPWR _0723_ sky130_fd_sc_hd__xor2_2
XFILLER_0_43_169 VGND VGND VPWR VPWR sky130_fd_sc_hd__decap_6
XFILLER_0_51_191 VGND VGND VPWR VPWR sky130_fd_sc_hd__decap_4
X_3544_ _0626_ _0654_ VGND VGND VPWR VPWR _0655_ sky130_fd_sc_hd__xor2_2
X_3475_ _0488_ _0500_ _0585_ _0586_ VGND VGND VPWR VPWR _0587_ sky130_fd_sc_hd__a211oi_1
X_2426_ _1452_ _1455_ _1469_ VGND VGND VPWR VPWR _1620_ sky130_fd_sc_hd__a21o_1
XFILLER_0_36_3 VGND VGND VPWR VPWR sky130_fd_sc_hd__decap_8
X_2357_ _0940_ _0951_ _1372_ _0918_ VGND VGND VPWR VPWR _1564_ sky130_fd_sc_hd__o31a_1
X_2288_ _1488_ _1501_ VGND VGND VPWR VPWR _1508_ sky130_fd_sc_hd__nor2_2
X_4027_ _1159_ _1162_ VGND VGND VPWR VPWR _1163_ sky130_fd_sc_hd__xnor2_1
XFILLER_0_74_283 VPWR VGND VPWR VGND sky130_ef_sc_hd__decap_12
XFILLER_0_34_158 VGND VGND VPWR VPWR sky130_fd_sc_hd__fill_1
XFILLER_0_62_445 VPWR VGND VPWR VGND sky130_ef_sc_hd__decap_12
XFILLER_0_57_217 VGND VGND VPWR VPWR sky130_fd_sc_hd__decap_3
XFILLER_0_57_239 VGND VGND VPWR VPWR sky130_fd_sc_hd__decap_4
XFILLER_0_31_15 VGND VGND VPWR VPWR sky130_fd_sc_hd__decap_3
XFILLER_0_53_423 VPWR VGND VPWR VGND sky130_ef_sc_hd__decap_12
XFILLER_0_0_225 VGND VGND VPWR VPWR sky130_fd_sc_hd__fill_2
XTAP_504 VGND VPWR sky130_fd_sc_hd__tapvpwrvgnd_1
XTAP_515 VGND VPWR sky130_fd_sc_hd__tapvpwrvgnd_1
XTAP_526 VGND VPWR sky130_fd_sc_hd__tapvpwrvgnd_1
XTAP_537 VGND VPWR sky130_fd_sc_hd__tapvpwrvgnd_1
XTAP_548 VGND VPWR sky130_fd_sc_hd__tapvpwrvgnd_1
X_3260_ _0372_ _0368_ _0370_ VGND VGND VPWR VPWR _0374_ sky130_fd_sc_hd__nand3_1
XTAP_559 VGND VPWR sky130_fd_sc_hd__tapvpwrvgnd_1
X_3191_ _0262_ _0263_ _0303_ _0304_ VGND VGND VPWR VPWR _0306_ sky130_fd_sc_hd__or4bb_4
X_2211_ _1428_ VGND VGND VPWR VPWR _1435_ sky130_fd_sc_hd__inv_2
X_2142_ _0962_ _0973_ VGND VGND VPWR VPWR _0984_ sky130_fd_sc_hd__nand2_1
X_2975_ _0090_ _0091_ VGND VGND VPWR VPWR _0092_ sky130_fd_sc_hd__xor2_2
XFILLER_0_44_456 VGND VGND VPWR VPWR sky130_fd_sc_hd__decap_6
XFILLER_0_56_294 VGND VGND VPWR VPWR sky130_fd_sc_hd__fill_1
XFILLER_0_21_81 VGND VGND VPWR VPWR sky130_fd_sc_hd__decap_4
X_3527_ _0627_ _0637_ VGND VGND VPWR VPWR _0638_ sky130_fd_sc_hd__xnor2_2
X_3458_ _2007_ _0569_ _0471_ _0203_ VGND VGND VPWR VPWR _0570_ sky130_fd_sc_hd__a22oi_1
X_2409_ _1606_ VGND VGND VPWR VPWR _0026_ sky130_fd_sc_hd__clkbuf_1
X_3389_ _0499_ _0500_ _0420_ _0410_ VGND VGND VPWR VPWR _0502_ sky130_fd_sc_hd__a211oi_2
XFILLER_0_47_250 VPWR VGND VPWR VGND sky130_ef_sc_hd__decap_12
XFILLER_0_62_231 VGND VGND VPWR VPWR sky130_fd_sc_hd__fill_1
XFILLER_0_7_391 VGND VGND VPWR VPWR sky130_fd_sc_hd__fill_1
XFILLER_0_62_253 VGND VGND VPWR VPWR sky130_fd_sc_hd__decap_8
XFILLER_0_62_264 VPWR VGND VPWR VGND sky130_ef_sc_hd__decap_12
Xhold60 add_tmp\[15\] VGND VGND VPWR VPWR net133 sky130_fd_sc_hd__dlygate4sd3_1
XFILLER_0_5_317 VGND VGND VPWR VPWR sky130_fd_sc_hd__decap_8
XFILLER_0_26_456 VGND VGND VPWR VPWR sky130_fd_sc_hd__fill_1
X_2760_ _1720_ VGND VGND VPWR VPWR _1937_ sky130_fd_sc_hd__buf_4
X_2691_ _1695_ _1866_ _1867_ _1868_ VGND VGND VPWR VPWR _1869_ sky130_fd_sc_hd__nand4_4
XFILLER_0_53_253 VGND VGND VPWR VPWR sky130_fd_sc_hd__fill_1
XTAP_312 VGND VPWR sky130_fd_sc_hd__tapvpwrvgnd_1
XTAP_301 VGND VPWR sky130_fd_sc_hd__tapvpwrvgnd_1
X_4292_ clknet_3_0__leaf_clk _0037_ net35 VGND VGND VPWR VPWR net64 sky130_fd_sc_hd__dfrtp_1
XTAP_323 VGND VPWR sky130_fd_sc_hd__tapvpwrvgnd_1
X_3312_ _1687_ _0327_ _0422_ _0423_ VGND VGND VPWR VPWR _0425_ sky130_fd_sc_hd__a22o_1
XFILLER_0_67_33 VGND VGND VPWR VPWR sky130_fd_sc_hd__fill_1
XTAP_334 VGND VPWR sky130_fd_sc_hd__tapvpwrvgnd_1
XTAP_345 VGND VPWR sky130_fd_sc_hd__tapvpwrvgnd_1
XTAP_356 VGND VPWR sky130_fd_sc_hd__tapvpwrvgnd_1
XTAP_367 VGND VPWR sky130_fd_sc_hd__tapvpwrvgnd_1
X_3243_ _0111_ VGND VGND VPWR VPWR _0357_ sky130_fd_sc_hd__buf_2
XTAP_378 VGND VPWR sky130_fd_sc_hd__tapvpwrvgnd_1
XTAP_389 VGND VPWR sky130_fd_sc_hd__tapvpwrvgnd_1
X_3174_ _2007_ VGND VGND VPWR VPWR _0289_ sky130_fd_sc_hd__clkbuf_2
Xrebuffer36 _2031_ VGND VGND VPWR VPWR net109 sky130_fd_sc_hd__buf_1
Xrebuffer25 _0095_ VGND VGND VPWR VPWR net98 sky130_fd_sc_hd__clkbuf_1
Xrebuffer14 _0221_ VGND VGND VPWR VPWR net87 sky130_fd_sc_hd__buf_1
XPHY_29 VGND VGND VPWR VPWR sky130_fd_sc_hd__decap_3
XPHY_18 VGND VGND VPWR VPWR sky130_fd_sc_hd__decap_3
Xrebuffer47 _2107_ VGND VGND VPWR VPWR net120 sky130_fd_sc_hd__buf_1
Xrebuffer58 _0132_ VGND VGND VPWR VPWR net144 sky130_fd_sc_hd__dlygate4sd1_1
XFILLER_0_16_92 VPWR VGND VPWR VGND sky130_ef_sc_hd__decap_12
XFILLER_0_76_345 VPWR VGND VPWR VGND sky130_ef_sc_hd__decap_12
XFILLER_0_8_100 VGND VGND VPWR VPWR sky130_fd_sc_hd__decap_6
XFILLER_0_8_133 VGND VGND VPWR VPWR sky130_fd_sc_hd__fill_2
X_2958_ _2071_ net82 _2112_ VGND VGND VPWR VPWR _0075_ sky130_fd_sc_hd__nand3_1
X_2889_ _2063_ VGND VGND VPWR VPWR _2064_ sky130_fd_sc_hd__clkbuf_2
XFILLER_0_4_394 VPWR VGND VPWR VGND sky130_ef_sc_hd__decap_12
XFILLER_0_4_372 VGND VGND VPWR VPWR sky130_fd_sc_hd__decap_6
XFILLER_0_12_194 VGND VGND VPWR VPWR sky130_fd_sc_hd__fill_2
XFILLER_0_67_312 VGND VGND VPWR VPWR sky130_fd_sc_hd__fill_2
XFILLER_0_2_309 VPWR VGND VPWR VGND sky130_ef_sc_hd__decap_12
XFILLER_0_50_201 VGND VGND VPWR VPWR sky130_fd_sc_hd__decap_3
Xoutput50 net50 VGND VGND VPWR VPWR out_acc[22] sky130_fd_sc_hd__clkbuf_4
Xoutput61 net61 VGND VGND VPWR VPWR out_acc[32] sky130_fd_sc_hd__clkbuf_4
Xoutput72 net72 VGND VGND VPWR VPWR ovf sky130_fd_sc_hd__clkbuf_4
XFILLER_0_77_109 VGND VGND VPWR VPWR sky130_fd_sc_hd__decap_3
XFILLER_0_53_35 VGND VGND VPWR VPWR sky130_fd_sc_hd__decap_6
X_3930_ _0961_ _1039_ _1056_ VGND VGND VPWR VPWR _1057_ sky130_fd_sc_hd__a21bo_1
XFILLER_0_53_57 VPWR VGND VPWR VGND sky130_ef_sc_hd__decap_12
XFILLER_0_58_389 VGND VGND VPWR VPWR sky130_fd_sc_hd__decap_8
X_3861_ _0827_ _0809_ _0903_ VGND VGND VPWR VPWR _0983_ sky130_fd_sc_hd__a21o_1
XFILLER_0_73_315 VPWR VGND VPWR VGND sky130_ef_sc_hd__decap_12
X_2812_ _1987_ _1988_ VGND VGND VPWR VPWR _1989_ sky130_fd_sc_hd__or2_1
X_3792_ _0906_ _0907_ VGND VGND VPWR VPWR _0909_ sky130_fd_sc_hd__xnor2_1
XFILLER_0_73_337 VPWR VGND VPWR VGND sky130_ef_sc_hd__decap_12
XFILLER_0_14_404 VGND VGND VPWR VPWR sky130_fd_sc_hd__fill_2
XFILLER_0_5_125 VPWR VGND VPWR VGND sky130_ef_sc_hd__decap_12
X_2743_ _1808_ _1860_ _1919_ _1920_ VGND VGND VPWR VPWR _1921_ sky130_fd_sc_hd__nand4_2
XFILLER_0_14_448 VPWR VGND VPWR VGND sky130_ef_sc_hd__decap_12
XFILLER_0_14_415 VGND VGND VPWR VPWR sky130_fd_sc_hd__decap_4
XFILLER_0_5_169 VGND VGND VPWR VPWR sky130_fd_sc_hd__decap_3
X_2674_ _1850_ _1851_ _1824_ VGND VGND VPWR VPWR _1853_ sky130_fd_sc_hd__a21o_1
X_4275_ clknet_3_4__leaf_clk _0020_ net35 VGND VGND VPWR VPWR net45 sky130_fd_sc_hd__dfrtp_1
XTAP_164 VGND VPWR sky130_fd_sc_hd__tapvpwrvgnd_1
XTAP_175 VGND VPWR sky130_fd_sc_hd__tapvpwrvgnd_1
XTAP_186 VGND VPWR sky130_fd_sc_hd__tapvpwrvgnd_1
XTAP_197 VGND VPWR sky130_fd_sc_hd__tapvpwrvgnd_1
X_3226_ _2094_ VGND VGND VPWR VPWR _0340_ sky130_fd_sc_hd__clkbuf_2
X_3157_ _0266_ _0269_ _0271_ VGND VGND VPWR VPWR _0272_ sky130_fd_sc_hd__a21o_1
XFILLER_0_68_109 VPWR VGND VPWR VGND sky130_ef_sc_hd__decap_12
X_3088_ _0203_ VGND VGND VPWR VPWR _0204_ sky130_fd_sc_hd__clkbuf_2
XFILLER_0_76_197 VGND VGND VPWR VPWR sky130_fd_sc_hd__decap_8
XFILLER_0_17_231 VGND VGND VPWR VPWR sky130_fd_sc_hd__decap_8
XFILLER_0_17_286 VPWR VGND VPWR VGND sky130_ef_sc_hd__decap_12
XFILLER_0_20_429 VGND VGND VPWR VPWR sky130_fd_sc_hd__fill_1
XFILLER_0_7_90 VPWR VGND VPWR VGND sky130_ef_sc_hd__decap_12
XFILLER_0_59_109 VGND VGND VPWR VPWR sky130_fd_sc_hd__decap_3
XFILLER_0_23_16 VGND VGND VPWR VPWR sky130_fd_sc_hd__decap_8
XFILLER_0_55_337 VGND VGND VPWR VPWR sky130_fd_sc_hd__fill_1
XFILLER_0_70_318 VGND VGND VPWR VPWR sky130_fd_sc_hd__decap_4
Xrebuffer5 net77 VGND VGND VPWR VPWR net78 sky130_fd_sc_hd__clkbuf_1
XFILLER_0_23_245 VGND VGND VPWR VPWR sky130_fd_sc_hd__fill_1
XFILLER_0_11_429 VPWR VGND VPWR VGND sky130_ef_sc_hd__decap_12
XFILLER_0_48_35 VGND VGND VPWR VPWR sky130_fd_sc_hd__fill_1
X_2390_ _1430_ _1590_ _1422_ VGND VGND VPWR VPWR _1591_ sky130_fd_sc_hd__a21oi_1
X_4060_ _1192_ _1197_ VGND VGND VPWR VPWR _1198_ sky130_fd_sc_hd__xnor2_1
XFILLER_0_3_15 VPWR VGND VPWR VGND sky130_ef_sc_hd__decap_12
X_3011_ _0125_ _0126_ _0115_ VGND VGND VPWR VPWR _0128_ sky130_fd_sc_hd__a21o_1
XFILLER_0_64_34 VPWR VGND VPWR VGND sky130_ef_sc_hd__decap_12
X_3913_ _0961_ _1039_ VGND VGND VPWR VPWR _1040_ sky130_fd_sc_hd__xnor2_1
XFILLER_0_46_304 VGND VGND VPWR VPWR sky130_fd_sc_hd__decap_4
XFILLER_0_58_153 VGND VGND VPWR VPWR sky130_fd_sc_hd__decap_8
XFILLER_0_73_101 VGND VGND VPWR VPWR sky130_fd_sc_hd__fill_1
X_3844_ _0961_ _0964_ VGND VGND VPWR VPWR _0965_ sky130_fd_sc_hd__nor2_1
XFILLER_0_58_197 VPWR VGND VPWR VGND sky130_ef_sc_hd__decap_12
XFILLER_0_13_82 VGND VGND VPWR VPWR sky130_fd_sc_hd__decap_4
XFILLER_0_6_445 VPWR VGND VPWR VGND sky130_ef_sc_hd__decap_12
XFILLER_0_73_145 VGND VGND VPWR VPWR sky130_fd_sc_hd__fill_2
X_3775_ _0561_ _0520_ _0767_ _0889_ _0766_ VGND VGND VPWR VPWR _0890_ sky130_fd_sc_hd__a311oi_1
X_2726_ _1899_ _1901_ net3 _1903_ VGND VGND VPWR VPWR _1904_ sky130_fd_sc_hd__and4bb_1
XFILLER_0_14_289 VGND VGND VPWR VPWR sky130_fd_sc_hd__decap_3
X_2657_ _1834_ _1832_ _1833_ VGND VGND VPWR VPWR _1836_ sky130_fd_sc_hd__nand3_1
X_2588_ _1738_ _1768_ VGND VGND VPWR VPWR _1769_ sky130_fd_sc_hd__xor2_1
X_4258_ clknet_3_1__leaf_clk _0003_ net35 VGND VGND VPWR VPWR net47 sky130_fd_sc_hd__dfrtp_4
X_3209_ net146 _0318_ _0322_ VGND VGND VPWR VPWR _0323_ sky130_fd_sc_hd__a21oi_1
X_4189_ _1285_ _1335_ VGND VGND VPWR VPWR _1337_ sky130_fd_sc_hd__or2_1
XFILLER_0_49_153 VGND VGND VPWR VPWR sky130_fd_sc_hd__fill_1
XFILLER_0_37_337 VGND VGND VPWR VPWR sky130_fd_sc_hd__decap_4
XFILLER_0_64_123 VGND VGND VPWR VPWR sky130_fd_sc_hd__decap_8
XFILLER_0_52_307 VGND VGND VPWR VPWR sky130_fd_sc_hd__fill_1
XFILLER_0_64_156 VGND VGND VPWR VPWR sky130_fd_sc_hd__fill_2
XFILLER_0_45_381 VGND VGND VPWR VPWR sky130_fd_sc_hd__decap_8
XFILLER_0_28_315 VPWR VGND VPWR VGND sky130_ef_sc_hd__decap_12
XFILLER_0_55_167 VGND VGND VPWR VPWR sky130_fd_sc_hd__fill_1
XFILLER_0_36_370 VGND VGND VPWR VPWR sky130_fd_sc_hd__decap_4
XFILLER_0_36_381 VPWR VGND VPWR VGND sky130_ef_sc_hd__decap_12
X_3560_ _0518_ _0606_ _0605_ VGND VGND VPWR VPWR _0670_ sky130_fd_sc_hd__a21o_1
XFILLER_0_11_204 VGND VGND VPWR VPWR sky130_fd_sc_hd__decap_3
X_2511_ net12 VGND VGND VPWR VPWR _1694_ sky130_fd_sc_hd__clkbuf_2
X_3491_ _0375_ _0402_ _0601_ VGND VGND VPWR VPWR _0602_ sky130_fd_sc_hd__o21ba_1
X_2442_ _1461_ _1462_ _1627_ _1516_ VGND VGND VPWR VPWR _1633_ sky130_fd_sc_hd__a31o_1
X_2373_ clr_delay VGND VGND VPWR VPWR _1577_ sky130_fd_sc_hd__buf_2
XFILLER_0_52_9 VGND VGND VPWR VPWR sky130_fd_sc_hd__decap_4
XFILLER_0_75_55 VGND VGND VPWR VPWR sky130_fd_sc_hd__fill_1
X_4112_ _1213_ _1212_ VGND VGND VPWR VPWR _1255_ sky130_fd_sc_hd__and2b_1
X_4043_ _1111_ _1174_ _1175_ VGND VGND VPWR VPWR _1180_ sky130_fd_sc_hd__o21ai_2
XFILLER_0_74_421 VPWR VGND VPWR VGND sky130_ef_sc_hd__decap_12
XFILLER_0_19_337 VGND VGND VPWR VPWR sky130_fd_sc_hd__decap_8
XFILLER_0_46_101 VGND VGND VPWR VPWR sky130_fd_sc_hd__fill_2
X_3827_ _0943_ _0944_ _0945_ VGND VGND VPWR VPWR _0946_ sky130_fd_sc_hd__a21o_1
X_3758_ _0865_ _0866_ _0870_ VGND VGND VPWR VPWR _0871_ sky130_fd_sc_hd__a21o_1
XFILLER_0_6_286 VPWR VGND VPWR VGND sky130_ef_sc_hd__decap_12
XFILLER_0_40_80 VGND VGND VPWR VPWR sky130_fd_sc_hd__decap_4
XFILLER_0_61_148 VGND VGND VPWR VPWR sky130_fd_sc_hd__fill_1
X_2709_ _1885_ _1875_ _1876_ VGND VGND VPWR VPWR _1887_ sky130_fd_sc_hd__nand3_1
X_3689_ _0778_ _0718_ _0796_ _0797_ VGND VGND VPWR VPWR _0798_ sky130_fd_sc_hd__a211o_1
XFILLER_0_77_281 VGND VGND VPWR VPWR sky130_fd_sc_hd__decap_8
XFILLER_0_37_167 VGND VGND VPWR VPWR sky130_fd_sc_hd__fill_1
XFILLER_0_25_329 VGND VGND VPWR VPWR sky130_fd_sc_hd__decap_6
XTAP_708 VGND VPWR sky130_fd_sc_hd__tapvpwrvgnd_1
XTAP_719 VGND VPWR sky130_fd_sc_hd__tapvpwrvgnd_1
XFILLER_0_45_36 VGND VGND VPWR VPWR sky130_fd_sc_hd__fill_1
XFILLER_0_45_69 VGND VGND VPWR VPWR sky130_fd_sc_hd__fill_2
XFILLER_0_0_16 VPWR VGND VPWR VGND sky130_ef_sc_hd__decap_12
X_2991_ _0107_ VGND VGND VPWR VPWR _0108_ sky130_fd_sc_hd__clkbuf_2
XFILLER_0_56_421 VGND VGND VPWR VPWR sky130_fd_sc_hd__decap_8
XFILLER_0_68_281 VGND VGND VPWR VPWR sky130_fd_sc_hd__decap_8
XFILLER_0_28_189 VGND VGND VPWR VPWR sky130_fd_sc_hd__decap_6
XFILLER_0_9_47 VGND VGND VPWR VPWR sky130_fd_sc_hd__fill_2
X_3612_ _0719_ _0721_ VGND VGND VPWR VPWR _0722_ sky130_fd_sc_hd__xor2_2
XFILLER_0_10_72 VGND VGND VPWR VPWR sky130_fd_sc_hd__fill_2
X_3543_ _0652_ _0653_ VGND VGND VPWR VPWR _0654_ sky130_fd_sc_hd__xnor2_2
X_3474_ _0583_ _0584_ _0527_ VGND VGND VPWR VPWR _0586_ sky130_fd_sc_hd__o21a_1
X_2425_ _1469_ _1452_ _1455_ VGND VGND VPWR VPWR _1619_ sky130_fd_sc_hd__and3_1
X_2356_ _0908_ _1383_ VGND VGND VPWR VPWR _1563_ sky130_fd_sc_hd__or2b_1
X_2287_ _1157_ _1505_ _1146_ VGND VGND VPWR VPWR _1507_ sky130_fd_sc_hd__and3_1
X_4026_ _1160_ _1161_ VGND VGND VPWR VPWR _1162_ sky130_fd_sc_hd__xnor2_1
XFILLER_0_35_91 VPWR VGND VPWR VGND sky130_ef_sc_hd__decap_12
XFILLER_0_19_167 VGND VGND VPWR VPWR sky130_fd_sc_hd__fill_1
XFILLER_0_74_273 VGND VGND VPWR VPWR sky130_fd_sc_hd__decap_4
XFILLER_0_62_457 VGND VGND VPWR VPWR sky130_fd_sc_hd__decap_6
XFILLER_0_74_295 VPWR VGND VPWR VGND sky130_ef_sc_hd__decap_12
Xclkbuf_3_0__f_clk clknet_0_clk VGND VGND VPWR VPWR clknet_3_0__leaf_clk sky130_fd_sc_hd__clkbuf_16
XFILLER_0_30_365 VPWR VGND VPWR VGND sky130_ef_sc_hd__decap_12
XFILLER_0_38_421 VGND VGND VPWR VPWR sky130_fd_sc_hd__fill_2
XFILLER_0_53_413 VGND VGND VPWR VPWR sky130_fd_sc_hd__fill_2
XFILLER_0_53_435 VPWR VGND VPWR VGND sky130_ef_sc_hd__decap_12
XFILLER_0_21_321 VGND VGND VPWR VPWR sky130_fd_sc_hd__decap_3
XFILLER_0_40_129 VGND VGND VPWR VPWR sky130_fd_sc_hd__fill_1
XFILLER_0_0_259 VPWR VGND VPWR VGND sky130_ef_sc_hd__decap_12
XTAP_505 VGND VPWR sky130_fd_sc_hd__tapvpwrvgnd_1
XTAP_516 VGND VPWR sky130_fd_sc_hd__tapvpwrvgnd_1
XTAP_527 VGND VPWR sky130_fd_sc_hd__tapvpwrvgnd_1
XTAP_538 VGND VPWR sky130_fd_sc_hd__tapvpwrvgnd_1
XTAP_549 VGND VPWR sky130_fd_sc_hd__tapvpwrvgnd_1
X_2210_ net51 add_tmp\[23\] VGND VGND VPWR VPWR _1434_ sky130_fd_sc_hd__nor2_1
XFILLER_0_56_24 VGND VGND VPWR VPWR sky130_fd_sc_hd__decap_4
X_3190_ _0262_ _0263_ _0303_ _0304_ VGND VGND VPWR VPWR _0305_ sky130_fd_sc_hd__a2bb2o_1
X_2141_ net39 add_tmp\[12\] VGND VGND VPWR VPWR _0973_ sky130_fd_sc_hd__or2_1
XFILLER_0_15_9 VPWR VGND VPWR VGND sky130_ef_sc_hd__decap_12
X_2974_ _2059_ _2062_ VGND VGND VPWR VPWR _0091_ sky130_fd_sc_hd__or2_4
XFILLER_0_44_413 VGND VGND VPWR VPWR sky130_fd_sc_hd__fill_2
X_3526_ _0635_ _0636_ VGND VGND VPWR VPWR _0637_ sky130_fd_sc_hd__and2b_1
XFILLER_0_12_365 VGND VGND VPWR VPWR sky130_fd_sc_hd__decap_4
X_3457_ _0077_ VGND VGND VPWR VPWR _0569_ sky130_fd_sc_hd__clkbuf_2
X_2408_ net52 _1605_ _1597_ VGND VGND VPWR VPWR _1606_ sky130_fd_sc_hd__mux2_1
X_3388_ _0420_ _0410_ _0499_ _0500_ VGND VGND VPWR VPWR _0501_ sky130_fd_sc_hd__o211a_1
X_2339_ net38 _1536_ _1537_ net132 _1549_ VGND VGND VPWR VPWR _0013_ sky130_fd_sc_hd__a221o_1
X_4009_ _0164_ _0327_ VGND VGND VPWR VPWR _1143_ sky130_fd_sc_hd__nand2_1
XFILLER_0_47_262 VPWR VGND VPWR VGND sky130_ef_sc_hd__decap_12
XFILLER_0_62_221 VGND VGND VPWR VPWR sky130_fd_sc_hd__decap_6
XFILLER_0_62_276 VGND VGND VPWR VPWR sky130_fd_sc_hd__decap_6
Xhold61 add_tmp\[28\] VGND VGND VPWR VPWR net134 sky130_fd_sc_hd__dlygate4sd3_1
XFILLER_0_26_402 VGND VGND VPWR VPWR sky130_fd_sc_hd__decap_8
XFILLER_0_38_273 VPWR VGND VPWR VGND sky130_ef_sc_hd__decap_12
X_2690_ net16 VGND VGND VPWR VPWR _1868_ sky130_fd_sc_hd__buf_4
XFILLER_0_41_449 VPWR VGND VPWR VGND sky130_ef_sc_hd__decap_12
XFILLER_0_6_15 VPWR VGND VPWR VGND sky130_ef_sc_hd__decap_12
XFILLER_0_21_140 VGND VGND VPWR VPWR sky130_fd_sc_hd__fill_1
X_3311_ _1687_ _0335_ _0422_ _0423_ VGND VGND VPWR VPWR _0424_ sky130_fd_sc_hd__nand4_4
XTAP_324 VGND VPWR sky130_fd_sc_hd__tapvpwrvgnd_1
XTAP_313 VGND VPWR sky130_fd_sc_hd__tapvpwrvgnd_1
XTAP_302 VGND VPWR sky130_fd_sc_hd__tapvpwrvgnd_1
X_4291_ clknet_3_0__leaf_clk _0036_ net35 VGND VGND VPWR VPWR net63 sky130_fd_sc_hd__dfrtp_2
XTAP_335 VGND VPWR sky130_fd_sc_hd__tapvpwrvgnd_1
XTAP_346 VGND VPWR sky130_fd_sc_hd__tapvpwrvgnd_1
XTAP_357 VGND VPWR sky130_fd_sc_hd__tapvpwrvgnd_1
X_3242_ _0111_ _1821_ _0353_ _0355_ VGND VGND VPWR VPWR _0356_ sky130_fd_sc_hd__a22o_1
XTAP_368 VGND VPWR sky130_fd_sc_hd__tapvpwrvgnd_1
XTAP_379 VGND VPWR sky130_fd_sc_hd__tapvpwrvgnd_1
X_3173_ _0284_ _0285_ _0286_ VGND VGND VPWR VPWR _0288_ sky130_fd_sc_hd__a21o_1
Xrebuffer15 net87 VGND VGND VPWR VPWR net88 sky130_fd_sc_hd__buf_6
Xrebuffer26 _0396_ VGND VGND VPWR VPWR net99 sky130_fd_sc_hd__clkbuf_1
XPHY_19 VGND VGND VPWR VPWR sky130_fd_sc_hd__decap_3
Xrebuffer59 _1982_ VGND VGND VPWR VPWR net145 sky130_fd_sc_hd__clkbuf_1
Xrebuffer37 _2108_ VGND VGND VPWR VPWR net110 sky130_fd_sc_hd__clkbuf_1
Xrebuffer48 _0283_ VGND VGND VPWR VPWR net121 sky130_fd_sc_hd__clkbuf_1
XFILLER_0_76_324 VGND VGND VPWR VPWR sky130_fd_sc_hd__fill_1
XFILLER_0_16_82 VGND VGND VPWR VPWR sky130_fd_sc_hd__fill_2
XFILLER_0_76_368 VPWR VGND VPWR VGND sky130_ef_sc_hd__decap_12
XFILLER_0_76_357 VGND VGND VPWR VPWR sky130_fd_sc_hd__fill_1
XFILLER_0_29_240 VGND VGND VPWR VPWR sky130_fd_sc_hd__decap_4
XFILLER_0_17_402 VGND VGND VPWR VPWR sky130_fd_sc_hd__fill_1
XFILLER_0_8_145 VPWR VGND VPWR VGND sky130_ef_sc_hd__decap_12
XFILLER_0_17_435 VPWR VGND VPWR VGND sky130_ef_sc_hd__decap_12
XFILLER_0_44_221 VGND VGND VPWR VPWR sky130_fd_sc_hd__decap_3
X_2957_ _2122_ _0072_ _0073_ VGND VGND VPWR VPWR _0074_ sky130_fd_sc_hd__and3_1
X_2888_ _2061_ VGND VGND VPWR VPWR _2063_ sky130_fd_sc_hd__clkbuf_2
X_3509_ _0618_ _0619_ VGND VGND VPWR VPWR _0620_ sky130_fd_sc_hd__xnor2_1
XFILLER_0_67_324 VPWR VGND VPWR VGND sky130_ef_sc_hd__decap_12
XFILLER_0_23_405 VGND VGND VPWR VPWR sky130_fd_sc_hd__fill_1
XFILLER_0_23_449 VPWR VGND VPWR VGND sky130_ef_sc_hd__decap_12
Xoutput51 net51 VGND VGND VPWR VPWR out_acc[23] sky130_fd_sc_hd__clkbuf_4
Xoutput40 net40 VGND VGND VPWR VPWR out_acc[13] sky130_fd_sc_hd__clkbuf_4
Xoutput62 net62 VGND VGND VPWR VPWR out_acc[33] sky130_fd_sc_hd__clkbuf_4
Xoutput73 net73 VGND VGND VPWR VPWR valid_out sky130_fd_sc_hd__clkbuf_4
XFILLER_0_53_69 VGND VGND VPWR VPWR sky130_fd_sc_hd__decap_6
XFILLER_0_58_324 VPWR VGND VPWR VGND sky130_ef_sc_hd__decap_12
X_3860_ _0818_ _0906_ VGND VGND VPWR VPWR _0982_ sky130_fd_sc_hd__or2_1
XFILLER_0_73_327 VGND VGND VPWR VPWR sky130_fd_sc_hd__decap_8
XFILLER_0_26_210 VGND VGND VPWR VPWR sky130_fd_sc_hd__fill_1
X_2811_ _1863_ _1921_ _1922_ _1985_ VGND VGND VPWR VPWR _1988_ sky130_fd_sc_hd__and4_1
X_3791_ _0816_ _0824_ VGND VGND VPWR VPWR _0907_ sky130_fd_sc_hd__nand2_1
XFILLER_0_73_349 VPWR VGND VPWR VGND sky130_ef_sc_hd__decap_12
XFILLER_0_5_137 VPWR VGND VPWR VGND sky130_ef_sc_hd__decap_12
X_2742_ _1809_ _1859_ _1917_ _1918_ VGND VGND VPWR VPWR _1920_ sky130_fd_sc_hd__a22o_1
XFILLER_0_26_298 VGND VGND VPWR VPWR sky130_fd_sc_hd__fill_2
XFILLER_0_1_310 VGND VGND VPWR VPWR sky130_fd_sc_hd__decap_3
X_2673_ _1824_ _1850_ _1851_ VGND VGND VPWR VPWR _1852_ sky130_fd_sc_hd__nand3_2
X_4274_ clknet_3_5__leaf_clk _0019_ net35 VGND VGND VPWR VPWR net44 sky130_fd_sc_hd__dfrtp_4
XTAP_165 VGND VPWR sky130_fd_sc_hd__tapvpwrvgnd_1
X_3225_ _0334_ _0336_ _0337_ VGND VGND VPWR VPWR _0339_ sky130_fd_sc_hd__a21o_1
XTAP_176 VGND VPWR sky130_fd_sc_hd__tapvpwrvgnd_1
XTAP_187 VGND VPWR sky130_fd_sc_hd__tapvpwrvgnd_1
XTAP_198 VGND VPWR sky130_fd_sc_hd__tapvpwrvgnd_1
X_3156_ _1934_ _0270_ VGND VGND VPWR VPWR _0271_ sky130_fd_sc_hd__and2_1
X_3087_ _1879_ VGND VGND VPWR VPWR _0203_ sky130_fd_sc_hd__buf_1
XFILLER_0_11_3 VPWR VGND VPWR VGND sky130_ef_sc_hd__decap_12
XFILLER_0_76_121 VPWR VGND VPWR VGND sky130_ef_sc_hd__decap_12
XFILLER_0_76_154 VGND VGND VPWR VPWR sky130_fd_sc_hd__decap_6
X_3989_ _1107_ _1108_ VGND VGND VPWR VPWR _1121_ sky130_fd_sc_hd__and2b_1
XFILLER_0_17_298 VPWR VGND VPWR VGND sky130_ef_sc_hd__decap_12
XFILLER_0_32_257 VGND VGND VPWR VPWR sky130_fd_sc_hd__fill_1
XFILLER_0_20_408 VPWR VGND VPWR VGND sky130_ef_sc_hd__decap_12
XFILLER_0_67_165 VGND VGND VPWR VPWR sky130_fd_sc_hd__decap_3
XFILLER_0_23_202 VPWR VGND VPWR VGND sky130_ef_sc_hd__decap_12
XFILLER_0_63_371 VGND VGND VPWR VPWR sky130_fd_sc_hd__decap_8
Xrebuffer6 net77 VGND VGND VPWR VPWR net79 sky130_fd_sc_hd__clkbuf_1
XFILLER_0_48_25 VGND VGND VPWR VPWR sky130_fd_sc_hd__decap_3
XFILLER_0_3_27 VPWR VGND VPWR VGND sky130_ef_sc_hd__decap_12
X_3010_ _0115_ _0125_ _0126_ VGND VGND VPWR VPWR _0127_ sky130_fd_sc_hd__nand3_2
XFILLER_0_64_46 VGND VGND VPWR VPWR sky130_fd_sc_hd__decap_8
X_3912_ _1033_ _1037_ VGND VGND VPWR VPWR _1039_ sky130_fd_sc_hd__xor2_1
X_3843_ _0291_ _0519_ _0844_ _0963_ _0843_ VGND VGND VPWR VPWR _0964_ sky130_fd_sc_hd__a311oi_1
XFILLER_0_6_457 VGND VGND VPWR VPWR sky130_fd_sc_hd__decap_6
X_3774_ _0561_ _0403_ VGND VGND VPWR VPWR _0889_ sky130_fd_sc_hd__nor2_1
X_2725_ net33 VGND VGND VPWR VPWR _1903_ sky130_fd_sc_hd__clkbuf_2
X_2656_ _1832_ _1833_ _1834_ VGND VGND VPWR VPWR _1835_ sky130_fd_sc_hd__a21o_1
XFILLER_0_10_441 VPWR VGND VPWR VGND sky130_ef_sc_hd__decap_12
X_2587_ _1718_ _1767_ VGND VGND VPWR VPWR _1768_ sky130_fd_sc_hd__xnor2_4
XFILLER_0_59_3 VGND VGND VPWR VPWR sky130_fd_sc_hd__decap_8
X_4257_ clknet_3_1__leaf_clk _0002_ net35 VGND VGND VPWR VPWR net36 sky130_fd_sc_hd__dfrtp_4
X_4188_ _1285_ _1335_ VGND VGND VPWR VPWR _1336_ sky130_fd_sc_hd__nand2_1
X_3208_ _0229_ _0313_ VGND VGND VPWR VPWR _0322_ sky130_fd_sc_hd__nor2_1
X_3139_ _0248_ _0253_ VGND VGND VPWR VPWR _0254_ sky130_fd_sc_hd__xor2_4
XFILLER_0_77_441 VGND VGND VPWR VPWR sky130_fd_sc_hd__decap_6
XFILLER_0_49_110 VGND VGND VPWR VPWR sky130_fd_sc_hd__fill_2
XFILLER_0_64_179 VGND VGND VPWR VPWR sky130_fd_sc_hd__decap_8
XFILLER_0_45_393 VGND VGND VPWR VPWR sky130_fd_sc_hd__decap_3
XFILLER_0_34_27 VGND VGND VPWR VPWR sky130_fd_sc_hd__fill_1
XFILLER_0_28_327 VGND VGND VPWR VPWR sky130_fd_sc_hd__decap_8
XFILLER_0_55_113 VGND VGND VPWR VPWR sky130_fd_sc_hd__fill_1
XFILLER_0_50_26 VGND VGND VPWR VPWR sky130_fd_sc_hd__fill_2
XFILLER_0_36_360 VGND VGND VPWR VPWR sky130_fd_sc_hd__decap_4
XFILLER_0_3_405 VPWR VGND VPWR VGND sky130_ef_sc_hd__decap_12
XFILLER_0_36_393 VPWR VGND VPWR VGND sky130_ef_sc_hd__decap_12
XFILLER_0_3_449 VPWR VGND VPWR VGND sky130_ef_sc_hd__decap_12
X_3490_ _0375_ _0519_ _0572_ _0571_ VGND VGND VPWR VPWR _0601_ sky130_fd_sc_hd__a31o_1
X_2510_ net26 VGND VGND VPWR VPWR _1693_ sky130_fd_sc_hd__buf_6
XFILLER_0_59_24 VPWR VGND VPWR VGND sky130_ef_sc_hd__decap_12
X_2441_ _1462_ _1627_ _1461_ VGND VGND VPWR VPWR _1632_ sky130_fd_sc_hd__a21oi_1
XFILLER_0_59_57 VGND VGND VPWR VPWR sky130_fd_sc_hd__decap_8
X_2372_ _1413_ _1575_ VGND VGND VPWR VPWR _1576_ sky130_fd_sc_hd__xor2_1
X_4111_ _1251_ _1252_ VGND VGND VPWR VPWR _1253_ sky130_fd_sc_hd__xnor2_1
X_4042_ _1178_ VGND VGND VPWR VPWR _0063_ sky130_fd_sc_hd__clkbuf_1
XFILLER_0_74_400 VGND VGND VPWR VPWR sky130_fd_sc_hd__decap_6
XFILLER_0_59_452 VGND VGND VPWR VPWR sky130_fd_sc_hd__decap_4
XFILLER_0_74_433 VPWR VGND VPWR VGND sky130_ef_sc_hd__decap_12
X_3826_ _0861_ _0862_ VGND VGND VPWR VPWR _0945_ sky130_fd_sc_hd__nand2_1
X_3757_ _1800_ _1818_ _0867_ _0869_ _0782_ VGND VGND VPWR VPWR _0870_ sky130_fd_sc_hd__a41o_1
XFILLER_0_6_298 VGND VGND VPWR VPWR sky130_fd_sc_hd__decap_8
X_2708_ _1875_ _1876_ _1885_ VGND VGND VPWR VPWR _1886_ sky130_fd_sc_hd__a21o_1
X_3688_ _0787_ _0788_ _0794_ _0795_ VGND VGND VPWR VPWR _0797_ sky130_fd_sc_hd__nor4_2
X_2639_ _1817_ VGND VGND VPWR VPWR _1818_ sky130_fd_sc_hd__buf_2
X_4309_ clknet_3_5__leaf_clk _0054_ net35 VGND VGND VPWR VPWR add_tmp\[16\] sky130_fd_sc_hd__dfrtp_1
XFILLER_0_37_113 VGND VGND VPWR VPWR sky130_fd_sc_hd__decap_8
XFILLER_0_0_419 VGND VGND VPWR VPWR sky130_fd_sc_hd__fill_1
XFILLER_0_60_160 VPWR VGND VPWR VGND sky130_ef_sc_hd__decap_12
XTAP_709 VGND VPWR sky130_fd_sc_hd__tapvpwrvgnd_1
XFILLER_0_28_124 VPWR VGND VPWR VGND sky130_ef_sc_hd__decap_12
X_2990_ _1827_ VGND VGND VPWR VPWR _0107_ sky130_fd_sc_hd__clkbuf_2
XFILLER_0_56_411 VGND VGND VPWR VPWR sky130_fd_sc_hd__fill_1
XFILLER_0_68_271 VGND VGND VPWR VPWR sky130_fd_sc_hd__decap_6
XFILLER_0_61_69 VGND VGND VPWR VPWR sky130_fd_sc_hd__fill_1
XFILLER_0_9_15 VPWR VGND VPWR VGND sky130_ef_sc_hd__decap_12
XFILLER_0_28_179 VGND VGND VPWR VPWR sky130_fd_sc_hd__decap_4
XFILLER_0_71_403 VGND VGND VPWR VPWR sky130_fd_sc_hd__decap_6
XFILLER_0_43_127 VGND VGND VPWR VPWR sky130_fd_sc_hd__fill_1
X_3611_ _0638_ _0651_ _0720_ VGND VGND VPWR VPWR _0721_ sky130_fd_sc_hd__o21ba_1
XFILLER_0_24_374 VGND VGND VPWR VPWR sky130_fd_sc_hd__decap_3
X_3542_ _0554_ _0544_ _0543_ VGND VGND VPWR VPWR _0653_ sky130_fd_sc_hd__a21bo_1
X_3473_ _0527_ _0583_ _0584_ VGND VGND VPWR VPWR _0585_ sky130_fd_sc_hd__nor3_1
X_2424_ _1508_ _1617_ _1618_ VGND VGND VPWR VPWR _0029_ sky130_fd_sc_hd__a21o_1
XFILLER_0_50_7 VGND VGND VPWR VPWR sky130_fd_sc_hd__fill_1
X_2355_ _1562_ VGND VGND VPWR VPWR _0016_ sky130_fd_sc_hd__clkbuf_1
X_2286_ _1157_ _1505_ _1146_ VGND VGND VPWR VPWR _1506_ sky130_fd_sc_hd__a21oi_1
X_4025_ _0837_ _0747_ VGND VGND VPWR VPWR _1161_ sky130_fd_sc_hd__or2_1
XFILLER_0_19_113 VPWR VGND VPWR VGND sky130_ef_sc_hd__decap_12
XFILLER_0_19_179 VGND VGND VPWR VPWR sky130_fd_sc_hd__decap_8
XFILLER_0_34_105 VGND VGND VPWR VPWR sky130_fd_sc_hd__fill_2
X_3809_ _0919_ _0920_ _0925_ VGND VGND VPWR VPWR _0926_ sky130_fd_sc_hd__a21o_1
XFILLER_0_15_385 VGND VGND VPWR VPWR sky130_fd_sc_hd__decap_6
XFILLER_0_42_160 VGND VGND VPWR VPWR sky130_fd_sc_hd__decap_3
XFILLER_0_30_377 VGND VGND VPWR VPWR sky130_fd_sc_hd__decap_6
XFILLER_0_15_29 VGND VGND VPWR VPWR sky130_fd_sc_hd__fill_1
XFILLER_0_31_39 VPWR VGND VPWR VGND sky130_ef_sc_hd__decap_12
XFILLER_0_53_447 VGND VGND VPWR VPWR sky130_fd_sc_hd__fill_1
XFILLER_0_18_190 VGND VGND VPWR VPWR sky130_fd_sc_hd__decap_6
XFILLER_0_0_205 VPWR VGND VPWR VGND sky130_ef_sc_hd__decap_12
XTAP_506 VGND VPWR sky130_fd_sc_hd__tapvpwrvgnd_1
XTAP_517 VGND VPWR sky130_fd_sc_hd__tapvpwrvgnd_1
XTAP_528 VGND VPWR sky130_fd_sc_hd__tapvpwrvgnd_1
XTAP_539 VGND VPWR sky130_fd_sc_hd__tapvpwrvgnd_1
XFILLER_0_56_14 VGND VGND VPWR VPWR sky130_fd_sc_hd__decap_3
XFILLER_0_56_69 VGND VGND VPWR VPWR sky130_fd_sc_hd__fill_1
X_2140_ net39 add_tmp\[12\] VGND VGND VPWR VPWR _0962_ sky130_fd_sc_hd__nand2_1
XFILLER_0_8_327 VGND VGND VPWR VPWR sky130_fd_sc_hd__fill_2
XFILLER_0_8_316 VGND VGND VPWR VPWR sky130_fd_sc_hd__decap_3
X_2973_ _0087_ net105 VGND VGND VPWR VPWR _0090_ sky130_fd_sc_hd__nor2_4
XFILLER_0_8_349 VGND VGND VPWR VPWR sky130_fd_sc_hd__fill_1
XFILLER_0_71_299 VGND VGND VPWR VPWR sky130_fd_sc_hd__fill_1
X_3525_ _0632_ _0634_ _0628_ VGND VGND VPWR VPWR _0636_ sky130_fd_sc_hd__a21o_1
X_3456_ _0564_ _0565_ _0566_ VGND VGND VPWR VPWR _0568_ sky130_fd_sc_hd__a21o_1
X_3387_ _0498_ _0488_ _0489_ VGND VGND VPWR VPWR _0500_ sky130_fd_sc_hd__nand3b_2
X_2407_ _1604_ add_tmp\[24\] _1577_ VGND VGND VPWR VPWR _1605_ sky130_fd_sc_hd__mux2_1
XFILLER_0_41_3 VPWR VGND VPWR VGND sky130_ef_sc_hd__decap_12
X_2338_ _1486_ _1548_ VGND VGND VPWR VPWR _1549_ sky130_fd_sc_hd__nor2_1
X_2269_ _1491_ VGND VGND VPWR VPWR _0001_ sky130_fd_sc_hd__clkbuf_1
X_4008_ _1974_ _2037_ _1141_ VGND VGND VPWR VPWR _1142_ sky130_fd_sc_hd__o21ai_1
XFILLER_0_46_80 VGND VGND VPWR VPWR sky130_fd_sc_hd__decap_4
XFILLER_0_1_82 VGND VGND VPWR VPWR sky130_fd_sc_hd__fill_1
XFILLER_0_62_90 VPWR VGND VPWR VGND sky130_ef_sc_hd__decap_12
XFILLER_0_47_274 VGND VGND VPWR VPWR sky130_fd_sc_hd__decap_6
XFILLER_0_35_447 VGND VGND VPWR VPWR sky130_fd_sc_hd__fill_1
XFILLER_0_7_393 VGND VGND VPWR VPWR sky130_fd_sc_hd__decap_8
XFILLER_0_62_299 VGND VGND VPWR VPWR sky130_fd_sc_hd__decap_8
XFILLER_0_15_182 VGND VGND VPWR VPWR sky130_fd_sc_hd__decap_8
Xhold62 add_tmp\[1\] VGND VGND VPWR VPWR net135 sky130_fd_sc_hd__dlygate4sd3_1
XFILLER_0_38_285 VGND VGND VPWR VPWR sky130_fd_sc_hd__decap_6
XFILLER_0_53_233 VGND VGND VPWR VPWR sky130_fd_sc_hd__decap_3
XFILLER_0_41_406 VGND VGND VPWR VPWR sky130_fd_sc_hd__decap_3
XFILLER_0_41_417 VGND VGND VPWR VPWR sky130_fd_sc_hd__fill_2
XFILLER_0_6_27 VGND VGND VPWR VPWR sky130_fd_sc_hd__fill_1
XFILLER_0_21_163 VGND VGND VPWR VPWR sky130_fd_sc_hd__decap_4
X_3310_ _0117_ _1937_ _0328_ VGND VGND VPWR VPWR _0423_ sky130_fd_sc_hd__o21a_2
XTAP_314 VGND VPWR sky130_fd_sc_hd__tapvpwrvgnd_1
XTAP_303 VGND VPWR sky130_fd_sc_hd__tapvpwrvgnd_1
X_4290_ clknet_3_0__leaf_clk _0035_ net35 VGND VGND VPWR VPWR net62 sky130_fd_sc_hd__dfrtp_4
XFILLER_0_21_196 VGND VGND VPWR VPWR sky130_fd_sc_hd__fill_1
XFILLER_0_67_57 VGND VGND VPWR VPWR sky130_fd_sc_hd__fill_2
XTAP_325 VGND VPWR sky130_fd_sc_hd__tapvpwrvgnd_1
XTAP_336 VGND VPWR sky130_fd_sc_hd__tapvpwrvgnd_1
XTAP_347 VGND VPWR sky130_fd_sc_hd__tapvpwrvgnd_1
XTAP_358 VGND VPWR sky130_fd_sc_hd__tapvpwrvgnd_1
X_3241_ _1787_ _1959_ _1940_ _0354_ VGND VGND VPWR VPWR _0355_ sky130_fd_sc_hd__nand4_2
XTAP_369 VGND VPWR sky130_fd_sc_hd__tapvpwrvgnd_1
X_3172_ _0284_ _0285_ _0286_ VGND VGND VPWR VPWR _0287_ sky130_fd_sc_hd__nand3_4
Xrebuffer16 _1968_ VGND VGND VPWR VPWR net89 sky130_fd_sc_hd__buf_1
Xrebuffer27 _0115_ VGND VGND VPWR VPWR net100 sky130_fd_sc_hd__clkbuf_1
XFILLER_0_16_50 VGND VGND VPWR VPWR sky130_fd_sc_hd__decap_8
Xrebuffer49 _0280_ VGND VGND VPWR VPWR net122 sky130_fd_sc_hd__clkbuf_1
Xrebuffer38 _2115_ VGND VGND VPWR VPWR net111 sky130_fd_sc_hd__clkbuf_2
XFILLER_0_17_447 VGND VGND VPWR VPWR sky130_fd_sc_hd__fill_1
XFILLER_0_8_157 VGND VGND VPWR VPWR sky130_fd_sc_hd__fill_1
X_2956_ _1987_ _1988_ _1993_ _2052_ _2121_ VGND VGND VPWR VPWR _0073_ sky130_fd_sc_hd__o311ai_2
X_2887_ _2059_ _2060_ net3 _2061_ VGND VGND VPWR VPWR _2062_ sky130_fd_sc_hd__and4b_1
XFILLER_0_4_363 VGND VGND VPWR VPWR sky130_fd_sc_hd__fill_1
XFILLER_0_12_152 VPWR VGND VPWR VGND sky130_ef_sc_hd__decap_12
X_3508_ _0203_ net24 VGND VGND VPWR VPWR _0619_ sky130_fd_sc_hd__nand2_1
X_3439_ _0546_ _0549_ _0550_ VGND VGND VPWR VPWR _0551_ sky130_fd_sc_hd__and3_1
XFILLER_0_7_190 VPWR VGND VPWR VGND sky130_ef_sc_hd__decap_12
XFILLER_0_35_277 VGND VGND VPWR VPWR sky130_fd_sc_hd__decap_3
Xoutput52 net52 VGND VGND VPWR VPWR out_acc[24] sky130_fd_sc_hd__clkbuf_4
Xoutput41 net41 VGND VGND VPWR VPWR out_acc[14] sky130_fd_sc_hd__clkbuf_4
Xoutput63 net63 VGND VGND VPWR VPWR out_acc[34] sky130_fd_sc_hd__clkbuf_4
XFILLER_0_58_336 VGND VGND VPWR VPWR sky130_fd_sc_hd__decap_6
X_2810_ _1921_ _1985_ VGND VGND VPWR VPWR _1987_ sky130_fd_sc_hd__and2b_1
X_3790_ _0904_ _0905_ VGND VGND VPWR VPWR _0906_ sky130_fd_sc_hd__or2_4
XFILLER_0_66_391 VGND VGND VPWR VPWR sky130_fd_sc_hd__fill_1
XFILLER_0_26_233 VPWR VGND VPWR VGND sky130_ef_sc_hd__decap_12
X_2741_ _1809_ _1860_ _1917_ _1918_ VGND VGND VPWR VPWR _1919_ sky130_fd_sc_hd__nand4_2
XFILLER_0_5_149 VGND VGND VPWR VPWR sky130_fd_sc_hd__decap_8
X_2672_ _1849_ _1847_ _1848_ VGND VGND VPWR VPWR _1851_ sky130_fd_sc_hd__nand3_2
XFILLER_0_1_333 VGND VGND VPWR VPWR sky130_fd_sc_hd__decap_3
X_4273_ clknet_3_5__leaf_clk _0018_ net35 VGND VGND VPWR VPWR net43 sky130_fd_sc_hd__dfrtp_2
XTAP_166 VGND VPWR sky130_fd_sc_hd__tapvpwrvgnd_1
X_3224_ _0334_ _0336_ _0337_ VGND VGND VPWR VPWR _0338_ sky130_fd_sc_hd__nand3_1
.ends
